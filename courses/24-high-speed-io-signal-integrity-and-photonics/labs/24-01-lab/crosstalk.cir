* 24-01 lab: near- and far-end crosstalk on a coupled microstrip pair (Example 24-01.7)
* A 200-section lumped ladder of two 50 ohm lines, 50 mm long, eps_eff = 3.0,
* L' = 2.888677e-07 H/m and C' = 1.155471e-10 F/m per line, Cm/C = 0.04, Lm/L = 0.06.
* The aggressor is driven through 50 ohm (launching 0.4 V, 30 ps ramp); all four ends see 50 ohm.
* Generated by make_crosstalk.py in this folder; edit that, not this file.
* EXPECT next key:../../chapters/24-01-signal-integrity-fundamentals.md#Ex_24-01.7d scale=1e-3 rtol=0.005
* EXPECT farea key:../../chapters/24-01-signal-integrity-fundamentals.md#Ex_24-01.7g scale=1e-12 rtol=0.002
Va src 0 PWL(0 0 50p 0 80p 0.8 2n 0.8)
Ras src a0 50
Rvn 0 v0 50
La0 a0 a1 7.221693e-11
Lv0 v0 v1 7.221693e-11
K0 La0 Lv0 0.06
Cag0 a1 0 2.773130e-14
Cvg0 v1 0 2.773130e-14
Cm0 a1 v1 1.155471e-15
La1 a1 a2 7.221693e-11
Lv1 v1 v2 7.221693e-11
K1 La1 Lv1 0.06
Cag1 a2 0 2.773130e-14
Cvg1 v2 0 2.773130e-14
Cm1 a2 v2 1.155471e-15
La2 a2 a3 7.221693e-11
Lv2 v2 v3 7.221693e-11
K2 La2 Lv2 0.06
Cag2 a3 0 2.773130e-14
Cvg2 v3 0 2.773130e-14
Cm2 a3 v3 1.155471e-15
La3 a3 a4 7.221693e-11
Lv3 v3 v4 7.221693e-11
K3 La3 Lv3 0.06
Cag3 a4 0 2.773130e-14
Cvg3 v4 0 2.773130e-14
Cm3 a4 v4 1.155471e-15
La4 a4 a5 7.221693e-11
Lv4 v4 v5 7.221693e-11
K4 La4 Lv4 0.06
Cag4 a5 0 2.773130e-14
Cvg4 v5 0 2.773130e-14
Cm4 a5 v5 1.155471e-15
La5 a5 a6 7.221693e-11
Lv5 v5 v6 7.221693e-11
K5 La5 Lv5 0.06
Cag5 a6 0 2.773130e-14
Cvg5 v6 0 2.773130e-14
Cm5 a6 v6 1.155471e-15
La6 a6 a7 7.221693e-11
Lv6 v6 v7 7.221693e-11
K6 La6 Lv6 0.06
Cag6 a7 0 2.773130e-14
Cvg6 v7 0 2.773130e-14
Cm6 a7 v7 1.155471e-15
La7 a7 a8 7.221693e-11
Lv7 v7 v8 7.221693e-11
K7 La7 Lv7 0.06
Cag7 a8 0 2.773130e-14
Cvg7 v8 0 2.773130e-14
Cm7 a8 v8 1.155471e-15
La8 a8 a9 7.221693e-11
Lv8 v8 v9 7.221693e-11
K8 La8 Lv8 0.06
Cag8 a9 0 2.773130e-14
Cvg8 v9 0 2.773130e-14
Cm8 a9 v9 1.155471e-15
La9 a9 a10 7.221693e-11
Lv9 v9 v10 7.221693e-11
K9 La9 Lv9 0.06
Cag9 a10 0 2.773130e-14
Cvg9 v10 0 2.773130e-14
Cm9 a10 v10 1.155471e-15
La10 a10 a11 7.221693e-11
Lv10 v10 v11 7.221693e-11
K10 La10 Lv10 0.06
Cag10 a11 0 2.773130e-14
Cvg10 v11 0 2.773130e-14
Cm10 a11 v11 1.155471e-15
La11 a11 a12 7.221693e-11
Lv11 v11 v12 7.221693e-11
K11 La11 Lv11 0.06
Cag11 a12 0 2.773130e-14
Cvg11 v12 0 2.773130e-14
Cm11 a12 v12 1.155471e-15
La12 a12 a13 7.221693e-11
Lv12 v12 v13 7.221693e-11
K12 La12 Lv12 0.06
Cag12 a13 0 2.773130e-14
Cvg12 v13 0 2.773130e-14
Cm12 a13 v13 1.155471e-15
La13 a13 a14 7.221693e-11
Lv13 v13 v14 7.221693e-11
K13 La13 Lv13 0.06
Cag13 a14 0 2.773130e-14
Cvg13 v14 0 2.773130e-14
Cm13 a14 v14 1.155471e-15
La14 a14 a15 7.221693e-11
Lv14 v14 v15 7.221693e-11
K14 La14 Lv14 0.06
Cag14 a15 0 2.773130e-14
Cvg14 v15 0 2.773130e-14
Cm14 a15 v15 1.155471e-15
La15 a15 a16 7.221693e-11
Lv15 v15 v16 7.221693e-11
K15 La15 Lv15 0.06
Cag15 a16 0 2.773130e-14
Cvg15 v16 0 2.773130e-14
Cm15 a16 v16 1.155471e-15
La16 a16 a17 7.221693e-11
Lv16 v16 v17 7.221693e-11
K16 La16 Lv16 0.06
Cag16 a17 0 2.773130e-14
Cvg16 v17 0 2.773130e-14
Cm16 a17 v17 1.155471e-15
La17 a17 a18 7.221693e-11
Lv17 v17 v18 7.221693e-11
K17 La17 Lv17 0.06
Cag17 a18 0 2.773130e-14
Cvg17 v18 0 2.773130e-14
Cm17 a18 v18 1.155471e-15
La18 a18 a19 7.221693e-11
Lv18 v18 v19 7.221693e-11
K18 La18 Lv18 0.06
Cag18 a19 0 2.773130e-14
Cvg18 v19 0 2.773130e-14
Cm18 a19 v19 1.155471e-15
La19 a19 a20 7.221693e-11
Lv19 v19 v20 7.221693e-11
K19 La19 Lv19 0.06
Cag19 a20 0 2.773130e-14
Cvg19 v20 0 2.773130e-14
Cm19 a20 v20 1.155471e-15
La20 a20 a21 7.221693e-11
Lv20 v20 v21 7.221693e-11
K20 La20 Lv20 0.06
Cag20 a21 0 2.773130e-14
Cvg20 v21 0 2.773130e-14
Cm20 a21 v21 1.155471e-15
La21 a21 a22 7.221693e-11
Lv21 v21 v22 7.221693e-11
K21 La21 Lv21 0.06
Cag21 a22 0 2.773130e-14
Cvg21 v22 0 2.773130e-14
Cm21 a22 v22 1.155471e-15
La22 a22 a23 7.221693e-11
Lv22 v22 v23 7.221693e-11
K22 La22 Lv22 0.06
Cag22 a23 0 2.773130e-14
Cvg22 v23 0 2.773130e-14
Cm22 a23 v23 1.155471e-15
La23 a23 a24 7.221693e-11
Lv23 v23 v24 7.221693e-11
K23 La23 Lv23 0.06
Cag23 a24 0 2.773130e-14
Cvg23 v24 0 2.773130e-14
Cm23 a24 v24 1.155471e-15
La24 a24 a25 7.221693e-11
Lv24 v24 v25 7.221693e-11
K24 La24 Lv24 0.06
Cag24 a25 0 2.773130e-14
Cvg24 v25 0 2.773130e-14
Cm24 a25 v25 1.155471e-15
La25 a25 a26 7.221693e-11
Lv25 v25 v26 7.221693e-11
K25 La25 Lv25 0.06
Cag25 a26 0 2.773130e-14
Cvg25 v26 0 2.773130e-14
Cm25 a26 v26 1.155471e-15
La26 a26 a27 7.221693e-11
Lv26 v26 v27 7.221693e-11
K26 La26 Lv26 0.06
Cag26 a27 0 2.773130e-14
Cvg26 v27 0 2.773130e-14
Cm26 a27 v27 1.155471e-15
La27 a27 a28 7.221693e-11
Lv27 v27 v28 7.221693e-11
K27 La27 Lv27 0.06
Cag27 a28 0 2.773130e-14
Cvg27 v28 0 2.773130e-14
Cm27 a28 v28 1.155471e-15
La28 a28 a29 7.221693e-11
Lv28 v28 v29 7.221693e-11
K28 La28 Lv28 0.06
Cag28 a29 0 2.773130e-14
Cvg28 v29 0 2.773130e-14
Cm28 a29 v29 1.155471e-15
La29 a29 a30 7.221693e-11
Lv29 v29 v30 7.221693e-11
K29 La29 Lv29 0.06
Cag29 a30 0 2.773130e-14
Cvg29 v30 0 2.773130e-14
Cm29 a30 v30 1.155471e-15
La30 a30 a31 7.221693e-11
Lv30 v30 v31 7.221693e-11
K30 La30 Lv30 0.06
Cag30 a31 0 2.773130e-14
Cvg30 v31 0 2.773130e-14
Cm30 a31 v31 1.155471e-15
La31 a31 a32 7.221693e-11
Lv31 v31 v32 7.221693e-11
K31 La31 Lv31 0.06
Cag31 a32 0 2.773130e-14
Cvg31 v32 0 2.773130e-14
Cm31 a32 v32 1.155471e-15
La32 a32 a33 7.221693e-11
Lv32 v32 v33 7.221693e-11
K32 La32 Lv32 0.06
Cag32 a33 0 2.773130e-14
Cvg32 v33 0 2.773130e-14
Cm32 a33 v33 1.155471e-15
La33 a33 a34 7.221693e-11
Lv33 v33 v34 7.221693e-11
K33 La33 Lv33 0.06
Cag33 a34 0 2.773130e-14
Cvg33 v34 0 2.773130e-14
Cm33 a34 v34 1.155471e-15
La34 a34 a35 7.221693e-11
Lv34 v34 v35 7.221693e-11
K34 La34 Lv34 0.06
Cag34 a35 0 2.773130e-14
Cvg34 v35 0 2.773130e-14
Cm34 a35 v35 1.155471e-15
La35 a35 a36 7.221693e-11
Lv35 v35 v36 7.221693e-11
K35 La35 Lv35 0.06
Cag35 a36 0 2.773130e-14
Cvg35 v36 0 2.773130e-14
Cm35 a36 v36 1.155471e-15
La36 a36 a37 7.221693e-11
Lv36 v36 v37 7.221693e-11
K36 La36 Lv36 0.06
Cag36 a37 0 2.773130e-14
Cvg36 v37 0 2.773130e-14
Cm36 a37 v37 1.155471e-15
La37 a37 a38 7.221693e-11
Lv37 v37 v38 7.221693e-11
K37 La37 Lv37 0.06
Cag37 a38 0 2.773130e-14
Cvg37 v38 0 2.773130e-14
Cm37 a38 v38 1.155471e-15
La38 a38 a39 7.221693e-11
Lv38 v38 v39 7.221693e-11
K38 La38 Lv38 0.06
Cag38 a39 0 2.773130e-14
Cvg38 v39 0 2.773130e-14
Cm38 a39 v39 1.155471e-15
La39 a39 a40 7.221693e-11
Lv39 v39 v40 7.221693e-11
K39 La39 Lv39 0.06
Cag39 a40 0 2.773130e-14
Cvg39 v40 0 2.773130e-14
Cm39 a40 v40 1.155471e-15
La40 a40 a41 7.221693e-11
Lv40 v40 v41 7.221693e-11
K40 La40 Lv40 0.06
Cag40 a41 0 2.773130e-14
Cvg40 v41 0 2.773130e-14
Cm40 a41 v41 1.155471e-15
La41 a41 a42 7.221693e-11
Lv41 v41 v42 7.221693e-11
K41 La41 Lv41 0.06
Cag41 a42 0 2.773130e-14
Cvg41 v42 0 2.773130e-14
Cm41 a42 v42 1.155471e-15
La42 a42 a43 7.221693e-11
Lv42 v42 v43 7.221693e-11
K42 La42 Lv42 0.06
Cag42 a43 0 2.773130e-14
Cvg42 v43 0 2.773130e-14
Cm42 a43 v43 1.155471e-15
La43 a43 a44 7.221693e-11
Lv43 v43 v44 7.221693e-11
K43 La43 Lv43 0.06
Cag43 a44 0 2.773130e-14
Cvg43 v44 0 2.773130e-14
Cm43 a44 v44 1.155471e-15
La44 a44 a45 7.221693e-11
Lv44 v44 v45 7.221693e-11
K44 La44 Lv44 0.06
Cag44 a45 0 2.773130e-14
Cvg44 v45 0 2.773130e-14
Cm44 a45 v45 1.155471e-15
La45 a45 a46 7.221693e-11
Lv45 v45 v46 7.221693e-11
K45 La45 Lv45 0.06
Cag45 a46 0 2.773130e-14
Cvg45 v46 0 2.773130e-14
Cm45 a46 v46 1.155471e-15
La46 a46 a47 7.221693e-11
Lv46 v46 v47 7.221693e-11
K46 La46 Lv46 0.06
Cag46 a47 0 2.773130e-14
Cvg46 v47 0 2.773130e-14
Cm46 a47 v47 1.155471e-15
La47 a47 a48 7.221693e-11
Lv47 v47 v48 7.221693e-11
K47 La47 Lv47 0.06
Cag47 a48 0 2.773130e-14
Cvg47 v48 0 2.773130e-14
Cm47 a48 v48 1.155471e-15
La48 a48 a49 7.221693e-11
Lv48 v48 v49 7.221693e-11
K48 La48 Lv48 0.06
Cag48 a49 0 2.773130e-14
Cvg48 v49 0 2.773130e-14
Cm48 a49 v49 1.155471e-15
La49 a49 a50 7.221693e-11
Lv49 v49 v50 7.221693e-11
K49 La49 Lv49 0.06
Cag49 a50 0 2.773130e-14
Cvg49 v50 0 2.773130e-14
Cm49 a50 v50 1.155471e-15
La50 a50 a51 7.221693e-11
Lv50 v50 v51 7.221693e-11
K50 La50 Lv50 0.06
Cag50 a51 0 2.773130e-14
Cvg50 v51 0 2.773130e-14
Cm50 a51 v51 1.155471e-15
La51 a51 a52 7.221693e-11
Lv51 v51 v52 7.221693e-11
K51 La51 Lv51 0.06
Cag51 a52 0 2.773130e-14
Cvg51 v52 0 2.773130e-14
Cm51 a52 v52 1.155471e-15
La52 a52 a53 7.221693e-11
Lv52 v52 v53 7.221693e-11
K52 La52 Lv52 0.06
Cag52 a53 0 2.773130e-14
Cvg52 v53 0 2.773130e-14
Cm52 a53 v53 1.155471e-15
La53 a53 a54 7.221693e-11
Lv53 v53 v54 7.221693e-11
K53 La53 Lv53 0.06
Cag53 a54 0 2.773130e-14
Cvg53 v54 0 2.773130e-14
Cm53 a54 v54 1.155471e-15
La54 a54 a55 7.221693e-11
Lv54 v54 v55 7.221693e-11
K54 La54 Lv54 0.06
Cag54 a55 0 2.773130e-14
Cvg54 v55 0 2.773130e-14
Cm54 a55 v55 1.155471e-15
La55 a55 a56 7.221693e-11
Lv55 v55 v56 7.221693e-11
K55 La55 Lv55 0.06
Cag55 a56 0 2.773130e-14
Cvg55 v56 0 2.773130e-14
Cm55 a56 v56 1.155471e-15
La56 a56 a57 7.221693e-11
Lv56 v56 v57 7.221693e-11
K56 La56 Lv56 0.06
Cag56 a57 0 2.773130e-14
Cvg56 v57 0 2.773130e-14
Cm56 a57 v57 1.155471e-15
La57 a57 a58 7.221693e-11
Lv57 v57 v58 7.221693e-11
K57 La57 Lv57 0.06
Cag57 a58 0 2.773130e-14
Cvg57 v58 0 2.773130e-14
Cm57 a58 v58 1.155471e-15
La58 a58 a59 7.221693e-11
Lv58 v58 v59 7.221693e-11
K58 La58 Lv58 0.06
Cag58 a59 0 2.773130e-14
Cvg58 v59 0 2.773130e-14
Cm58 a59 v59 1.155471e-15
La59 a59 a60 7.221693e-11
Lv59 v59 v60 7.221693e-11
K59 La59 Lv59 0.06
Cag59 a60 0 2.773130e-14
Cvg59 v60 0 2.773130e-14
Cm59 a60 v60 1.155471e-15
La60 a60 a61 7.221693e-11
Lv60 v60 v61 7.221693e-11
K60 La60 Lv60 0.06
Cag60 a61 0 2.773130e-14
Cvg60 v61 0 2.773130e-14
Cm60 a61 v61 1.155471e-15
La61 a61 a62 7.221693e-11
Lv61 v61 v62 7.221693e-11
K61 La61 Lv61 0.06
Cag61 a62 0 2.773130e-14
Cvg61 v62 0 2.773130e-14
Cm61 a62 v62 1.155471e-15
La62 a62 a63 7.221693e-11
Lv62 v62 v63 7.221693e-11
K62 La62 Lv62 0.06
Cag62 a63 0 2.773130e-14
Cvg62 v63 0 2.773130e-14
Cm62 a63 v63 1.155471e-15
La63 a63 a64 7.221693e-11
Lv63 v63 v64 7.221693e-11
K63 La63 Lv63 0.06
Cag63 a64 0 2.773130e-14
Cvg63 v64 0 2.773130e-14
Cm63 a64 v64 1.155471e-15
La64 a64 a65 7.221693e-11
Lv64 v64 v65 7.221693e-11
K64 La64 Lv64 0.06
Cag64 a65 0 2.773130e-14
Cvg64 v65 0 2.773130e-14
Cm64 a65 v65 1.155471e-15
La65 a65 a66 7.221693e-11
Lv65 v65 v66 7.221693e-11
K65 La65 Lv65 0.06
Cag65 a66 0 2.773130e-14
Cvg65 v66 0 2.773130e-14
Cm65 a66 v66 1.155471e-15
La66 a66 a67 7.221693e-11
Lv66 v66 v67 7.221693e-11
K66 La66 Lv66 0.06
Cag66 a67 0 2.773130e-14
Cvg66 v67 0 2.773130e-14
Cm66 a67 v67 1.155471e-15
La67 a67 a68 7.221693e-11
Lv67 v67 v68 7.221693e-11
K67 La67 Lv67 0.06
Cag67 a68 0 2.773130e-14
Cvg67 v68 0 2.773130e-14
Cm67 a68 v68 1.155471e-15
La68 a68 a69 7.221693e-11
Lv68 v68 v69 7.221693e-11
K68 La68 Lv68 0.06
Cag68 a69 0 2.773130e-14
Cvg68 v69 0 2.773130e-14
Cm68 a69 v69 1.155471e-15
La69 a69 a70 7.221693e-11
Lv69 v69 v70 7.221693e-11
K69 La69 Lv69 0.06
Cag69 a70 0 2.773130e-14
Cvg69 v70 0 2.773130e-14
Cm69 a70 v70 1.155471e-15
La70 a70 a71 7.221693e-11
Lv70 v70 v71 7.221693e-11
K70 La70 Lv70 0.06
Cag70 a71 0 2.773130e-14
Cvg70 v71 0 2.773130e-14
Cm70 a71 v71 1.155471e-15
La71 a71 a72 7.221693e-11
Lv71 v71 v72 7.221693e-11
K71 La71 Lv71 0.06
Cag71 a72 0 2.773130e-14
Cvg71 v72 0 2.773130e-14
Cm71 a72 v72 1.155471e-15
La72 a72 a73 7.221693e-11
Lv72 v72 v73 7.221693e-11
K72 La72 Lv72 0.06
Cag72 a73 0 2.773130e-14
Cvg72 v73 0 2.773130e-14
Cm72 a73 v73 1.155471e-15
La73 a73 a74 7.221693e-11
Lv73 v73 v74 7.221693e-11
K73 La73 Lv73 0.06
Cag73 a74 0 2.773130e-14
Cvg73 v74 0 2.773130e-14
Cm73 a74 v74 1.155471e-15
La74 a74 a75 7.221693e-11
Lv74 v74 v75 7.221693e-11
K74 La74 Lv74 0.06
Cag74 a75 0 2.773130e-14
Cvg74 v75 0 2.773130e-14
Cm74 a75 v75 1.155471e-15
La75 a75 a76 7.221693e-11
Lv75 v75 v76 7.221693e-11
K75 La75 Lv75 0.06
Cag75 a76 0 2.773130e-14
Cvg75 v76 0 2.773130e-14
Cm75 a76 v76 1.155471e-15
La76 a76 a77 7.221693e-11
Lv76 v76 v77 7.221693e-11
K76 La76 Lv76 0.06
Cag76 a77 0 2.773130e-14
Cvg76 v77 0 2.773130e-14
Cm76 a77 v77 1.155471e-15
La77 a77 a78 7.221693e-11
Lv77 v77 v78 7.221693e-11
K77 La77 Lv77 0.06
Cag77 a78 0 2.773130e-14
Cvg77 v78 0 2.773130e-14
Cm77 a78 v78 1.155471e-15
La78 a78 a79 7.221693e-11
Lv78 v78 v79 7.221693e-11
K78 La78 Lv78 0.06
Cag78 a79 0 2.773130e-14
Cvg78 v79 0 2.773130e-14
Cm78 a79 v79 1.155471e-15
La79 a79 a80 7.221693e-11
Lv79 v79 v80 7.221693e-11
K79 La79 Lv79 0.06
Cag79 a80 0 2.773130e-14
Cvg79 v80 0 2.773130e-14
Cm79 a80 v80 1.155471e-15
La80 a80 a81 7.221693e-11
Lv80 v80 v81 7.221693e-11
K80 La80 Lv80 0.06
Cag80 a81 0 2.773130e-14
Cvg80 v81 0 2.773130e-14
Cm80 a81 v81 1.155471e-15
La81 a81 a82 7.221693e-11
Lv81 v81 v82 7.221693e-11
K81 La81 Lv81 0.06
Cag81 a82 0 2.773130e-14
Cvg81 v82 0 2.773130e-14
Cm81 a82 v82 1.155471e-15
La82 a82 a83 7.221693e-11
Lv82 v82 v83 7.221693e-11
K82 La82 Lv82 0.06
Cag82 a83 0 2.773130e-14
Cvg82 v83 0 2.773130e-14
Cm82 a83 v83 1.155471e-15
La83 a83 a84 7.221693e-11
Lv83 v83 v84 7.221693e-11
K83 La83 Lv83 0.06
Cag83 a84 0 2.773130e-14
Cvg83 v84 0 2.773130e-14
Cm83 a84 v84 1.155471e-15
La84 a84 a85 7.221693e-11
Lv84 v84 v85 7.221693e-11
K84 La84 Lv84 0.06
Cag84 a85 0 2.773130e-14
Cvg84 v85 0 2.773130e-14
Cm84 a85 v85 1.155471e-15
La85 a85 a86 7.221693e-11
Lv85 v85 v86 7.221693e-11
K85 La85 Lv85 0.06
Cag85 a86 0 2.773130e-14
Cvg85 v86 0 2.773130e-14
Cm85 a86 v86 1.155471e-15
La86 a86 a87 7.221693e-11
Lv86 v86 v87 7.221693e-11
K86 La86 Lv86 0.06
Cag86 a87 0 2.773130e-14
Cvg86 v87 0 2.773130e-14
Cm86 a87 v87 1.155471e-15
La87 a87 a88 7.221693e-11
Lv87 v87 v88 7.221693e-11
K87 La87 Lv87 0.06
Cag87 a88 0 2.773130e-14
Cvg87 v88 0 2.773130e-14
Cm87 a88 v88 1.155471e-15
La88 a88 a89 7.221693e-11
Lv88 v88 v89 7.221693e-11
K88 La88 Lv88 0.06
Cag88 a89 0 2.773130e-14
Cvg88 v89 0 2.773130e-14
Cm88 a89 v89 1.155471e-15
La89 a89 a90 7.221693e-11
Lv89 v89 v90 7.221693e-11
K89 La89 Lv89 0.06
Cag89 a90 0 2.773130e-14
Cvg89 v90 0 2.773130e-14
Cm89 a90 v90 1.155471e-15
La90 a90 a91 7.221693e-11
Lv90 v90 v91 7.221693e-11
K90 La90 Lv90 0.06
Cag90 a91 0 2.773130e-14
Cvg90 v91 0 2.773130e-14
Cm90 a91 v91 1.155471e-15
La91 a91 a92 7.221693e-11
Lv91 v91 v92 7.221693e-11
K91 La91 Lv91 0.06
Cag91 a92 0 2.773130e-14
Cvg91 v92 0 2.773130e-14
Cm91 a92 v92 1.155471e-15
La92 a92 a93 7.221693e-11
Lv92 v92 v93 7.221693e-11
K92 La92 Lv92 0.06
Cag92 a93 0 2.773130e-14
Cvg92 v93 0 2.773130e-14
Cm92 a93 v93 1.155471e-15
La93 a93 a94 7.221693e-11
Lv93 v93 v94 7.221693e-11
K93 La93 Lv93 0.06
Cag93 a94 0 2.773130e-14
Cvg93 v94 0 2.773130e-14
Cm93 a94 v94 1.155471e-15
La94 a94 a95 7.221693e-11
Lv94 v94 v95 7.221693e-11
K94 La94 Lv94 0.06
Cag94 a95 0 2.773130e-14
Cvg94 v95 0 2.773130e-14
Cm94 a95 v95 1.155471e-15
La95 a95 a96 7.221693e-11
Lv95 v95 v96 7.221693e-11
K95 La95 Lv95 0.06
Cag95 a96 0 2.773130e-14
Cvg95 v96 0 2.773130e-14
Cm95 a96 v96 1.155471e-15
La96 a96 a97 7.221693e-11
Lv96 v96 v97 7.221693e-11
K96 La96 Lv96 0.06
Cag96 a97 0 2.773130e-14
Cvg96 v97 0 2.773130e-14
Cm96 a97 v97 1.155471e-15
La97 a97 a98 7.221693e-11
Lv97 v97 v98 7.221693e-11
K97 La97 Lv97 0.06
Cag97 a98 0 2.773130e-14
Cvg97 v98 0 2.773130e-14
Cm97 a98 v98 1.155471e-15
La98 a98 a99 7.221693e-11
Lv98 v98 v99 7.221693e-11
K98 La98 Lv98 0.06
Cag98 a99 0 2.773130e-14
Cvg98 v99 0 2.773130e-14
Cm98 a99 v99 1.155471e-15
La99 a99 a100 7.221693e-11
Lv99 v99 v100 7.221693e-11
K99 La99 Lv99 0.06
Cag99 a100 0 2.773130e-14
Cvg99 v100 0 2.773130e-14
Cm99 a100 v100 1.155471e-15
La100 a100 a101 7.221693e-11
Lv100 v100 v101 7.221693e-11
K100 La100 Lv100 0.06
Cag100 a101 0 2.773130e-14
Cvg100 v101 0 2.773130e-14
Cm100 a101 v101 1.155471e-15
La101 a101 a102 7.221693e-11
Lv101 v101 v102 7.221693e-11
K101 La101 Lv101 0.06
Cag101 a102 0 2.773130e-14
Cvg101 v102 0 2.773130e-14
Cm101 a102 v102 1.155471e-15
La102 a102 a103 7.221693e-11
Lv102 v102 v103 7.221693e-11
K102 La102 Lv102 0.06
Cag102 a103 0 2.773130e-14
Cvg102 v103 0 2.773130e-14
Cm102 a103 v103 1.155471e-15
La103 a103 a104 7.221693e-11
Lv103 v103 v104 7.221693e-11
K103 La103 Lv103 0.06
Cag103 a104 0 2.773130e-14
Cvg103 v104 0 2.773130e-14
Cm103 a104 v104 1.155471e-15
La104 a104 a105 7.221693e-11
Lv104 v104 v105 7.221693e-11
K104 La104 Lv104 0.06
Cag104 a105 0 2.773130e-14
Cvg104 v105 0 2.773130e-14
Cm104 a105 v105 1.155471e-15
La105 a105 a106 7.221693e-11
Lv105 v105 v106 7.221693e-11
K105 La105 Lv105 0.06
Cag105 a106 0 2.773130e-14
Cvg105 v106 0 2.773130e-14
Cm105 a106 v106 1.155471e-15
La106 a106 a107 7.221693e-11
Lv106 v106 v107 7.221693e-11
K106 La106 Lv106 0.06
Cag106 a107 0 2.773130e-14
Cvg106 v107 0 2.773130e-14
Cm106 a107 v107 1.155471e-15
La107 a107 a108 7.221693e-11
Lv107 v107 v108 7.221693e-11
K107 La107 Lv107 0.06
Cag107 a108 0 2.773130e-14
Cvg107 v108 0 2.773130e-14
Cm107 a108 v108 1.155471e-15
La108 a108 a109 7.221693e-11
Lv108 v108 v109 7.221693e-11
K108 La108 Lv108 0.06
Cag108 a109 0 2.773130e-14
Cvg108 v109 0 2.773130e-14
Cm108 a109 v109 1.155471e-15
La109 a109 a110 7.221693e-11
Lv109 v109 v110 7.221693e-11
K109 La109 Lv109 0.06
Cag109 a110 0 2.773130e-14
Cvg109 v110 0 2.773130e-14
Cm109 a110 v110 1.155471e-15
La110 a110 a111 7.221693e-11
Lv110 v110 v111 7.221693e-11
K110 La110 Lv110 0.06
Cag110 a111 0 2.773130e-14
Cvg110 v111 0 2.773130e-14
Cm110 a111 v111 1.155471e-15
La111 a111 a112 7.221693e-11
Lv111 v111 v112 7.221693e-11
K111 La111 Lv111 0.06
Cag111 a112 0 2.773130e-14
Cvg111 v112 0 2.773130e-14
Cm111 a112 v112 1.155471e-15
La112 a112 a113 7.221693e-11
Lv112 v112 v113 7.221693e-11
K112 La112 Lv112 0.06
Cag112 a113 0 2.773130e-14
Cvg112 v113 0 2.773130e-14
Cm112 a113 v113 1.155471e-15
La113 a113 a114 7.221693e-11
Lv113 v113 v114 7.221693e-11
K113 La113 Lv113 0.06
Cag113 a114 0 2.773130e-14
Cvg113 v114 0 2.773130e-14
Cm113 a114 v114 1.155471e-15
La114 a114 a115 7.221693e-11
Lv114 v114 v115 7.221693e-11
K114 La114 Lv114 0.06
Cag114 a115 0 2.773130e-14
Cvg114 v115 0 2.773130e-14
Cm114 a115 v115 1.155471e-15
La115 a115 a116 7.221693e-11
Lv115 v115 v116 7.221693e-11
K115 La115 Lv115 0.06
Cag115 a116 0 2.773130e-14
Cvg115 v116 0 2.773130e-14
Cm115 a116 v116 1.155471e-15
La116 a116 a117 7.221693e-11
Lv116 v116 v117 7.221693e-11
K116 La116 Lv116 0.06
Cag116 a117 0 2.773130e-14
Cvg116 v117 0 2.773130e-14
Cm116 a117 v117 1.155471e-15
La117 a117 a118 7.221693e-11
Lv117 v117 v118 7.221693e-11
K117 La117 Lv117 0.06
Cag117 a118 0 2.773130e-14
Cvg117 v118 0 2.773130e-14
Cm117 a118 v118 1.155471e-15
La118 a118 a119 7.221693e-11
Lv118 v118 v119 7.221693e-11
K118 La118 Lv118 0.06
Cag118 a119 0 2.773130e-14
Cvg118 v119 0 2.773130e-14
Cm118 a119 v119 1.155471e-15
La119 a119 a120 7.221693e-11
Lv119 v119 v120 7.221693e-11
K119 La119 Lv119 0.06
Cag119 a120 0 2.773130e-14
Cvg119 v120 0 2.773130e-14
Cm119 a120 v120 1.155471e-15
La120 a120 a121 7.221693e-11
Lv120 v120 v121 7.221693e-11
K120 La120 Lv120 0.06
Cag120 a121 0 2.773130e-14
Cvg120 v121 0 2.773130e-14
Cm120 a121 v121 1.155471e-15
La121 a121 a122 7.221693e-11
Lv121 v121 v122 7.221693e-11
K121 La121 Lv121 0.06
Cag121 a122 0 2.773130e-14
Cvg121 v122 0 2.773130e-14
Cm121 a122 v122 1.155471e-15
La122 a122 a123 7.221693e-11
Lv122 v122 v123 7.221693e-11
K122 La122 Lv122 0.06
Cag122 a123 0 2.773130e-14
Cvg122 v123 0 2.773130e-14
Cm122 a123 v123 1.155471e-15
La123 a123 a124 7.221693e-11
Lv123 v123 v124 7.221693e-11
K123 La123 Lv123 0.06
Cag123 a124 0 2.773130e-14
Cvg123 v124 0 2.773130e-14
Cm123 a124 v124 1.155471e-15
La124 a124 a125 7.221693e-11
Lv124 v124 v125 7.221693e-11
K124 La124 Lv124 0.06
Cag124 a125 0 2.773130e-14
Cvg124 v125 0 2.773130e-14
Cm124 a125 v125 1.155471e-15
La125 a125 a126 7.221693e-11
Lv125 v125 v126 7.221693e-11
K125 La125 Lv125 0.06
Cag125 a126 0 2.773130e-14
Cvg125 v126 0 2.773130e-14
Cm125 a126 v126 1.155471e-15
La126 a126 a127 7.221693e-11
Lv126 v126 v127 7.221693e-11
K126 La126 Lv126 0.06
Cag126 a127 0 2.773130e-14
Cvg126 v127 0 2.773130e-14
Cm126 a127 v127 1.155471e-15
La127 a127 a128 7.221693e-11
Lv127 v127 v128 7.221693e-11
K127 La127 Lv127 0.06
Cag127 a128 0 2.773130e-14
Cvg127 v128 0 2.773130e-14
Cm127 a128 v128 1.155471e-15
La128 a128 a129 7.221693e-11
Lv128 v128 v129 7.221693e-11
K128 La128 Lv128 0.06
Cag128 a129 0 2.773130e-14
Cvg128 v129 0 2.773130e-14
Cm128 a129 v129 1.155471e-15
La129 a129 a130 7.221693e-11
Lv129 v129 v130 7.221693e-11
K129 La129 Lv129 0.06
Cag129 a130 0 2.773130e-14
Cvg129 v130 0 2.773130e-14
Cm129 a130 v130 1.155471e-15
La130 a130 a131 7.221693e-11
Lv130 v130 v131 7.221693e-11
K130 La130 Lv130 0.06
Cag130 a131 0 2.773130e-14
Cvg130 v131 0 2.773130e-14
Cm130 a131 v131 1.155471e-15
La131 a131 a132 7.221693e-11
Lv131 v131 v132 7.221693e-11
K131 La131 Lv131 0.06
Cag131 a132 0 2.773130e-14
Cvg131 v132 0 2.773130e-14
Cm131 a132 v132 1.155471e-15
La132 a132 a133 7.221693e-11
Lv132 v132 v133 7.221693e-11
K132 La132 Lv132 0.06
Cag132 a133 0 2.773130e-14
Cvg132 v133 0 2.773130e-14
Cm132 a133 v133 1.155471e-15
La133 a133 a134 7.221693e-11
Lv133 v133 v134 7.221693e-11
K133 La133 Lv133 0.06
Cag133 a134 0 2.773130e-14
Cvg133 v134 0 2.773130e-14
Cm133 a134 v134 1.155471e-15
La134 a134 a135 7.221693e-11
Lv134 v134 v135 7.221693e-11
K134 La134 Lv134 0.06
Cag134 a135 0 2.773130e-14
Cvg134 v135 0 2.773130e-14
Cm134 a135 v135 1.155471e-15
La135 a135 a136 7.221693e-11
Lv135 v135 v136 7.221693e-11
K135 La135 Lv135 0.06
Cag135 a136 0 2.773130e-14
Cvg135 v136 0 2.773130e-14
Cm135 a136 v136 1.155471e-15
La136 a136 a137 7.221693e-11
Lv136 v136 v137 7.221693e-11
K136 La136 Lv136 0.06
Cag136 a137 0 2.773130e-14
Cvg136 v137 0 2.773130e-14
Cm136 a137 v137 1.155471e-15
La137 a137 a138 7.221693e-11
Lv137 v137 v138 7.221693e-11
K137 La137 Lv137 0.06
Cag137 a138 0 2.773130e-14
Cvg137 v138 0 2.773130e-14
Cm137 a138 v138 1.155471e-15
La138 a138 a139 7.221693e-11
Lv138 v138 v139 7.221693e-11
K138 La138 Lv138 0.06
Cag138 a139 0 2.773130e-14
Cvg138 v139 0 2.773130e-14
Cm138 a139 v139 1.155471e-15
La139 a139 a140 7.221693e-11
Lv139 v139 v140 7.221693e-11
K139 La139 Lv139 0.06
Cag139 a140 0 2.773130e-14
Cvg139 v140 0 2.773130e-14
Cm139 a140 v140 1.155471e-15
La140 a140 a141 7.221693e-11
Lv140 v140 v141 7.221693e-11
K140 La140 Lv140 0.06
Cag140 a141 0 2.773130e-14
Cvg140 v141 0 2.773130e-14
Cm140 a141 v141 1.155471e-15
La141 a141 a142 7.221693e-11
Lv141 v141 v142 7.221693e-11
K141 La141 Lv141 0.06
Cag141 a142 0 2.773130e-14
Cvg141 v142 0 2.773130e-14
Cm141 a142 v142 1.155471e-15
La142 a142 a143 7.221693e-11
Lv142 v142 v143 7.221693e-11
K142 La142 Lv142 0.06
Cag142 a143 0 2.773130e-14
Cvg142 v143 0 2.773130e-14
Cm142 a143 v143 1.155471e-15
La143 a143 a144 7.221693e-11
Lv143 v143 v144 7.221693e-11
K143 La143 Lv143 0.06
Cag143 a144 0 2.773130e-14
Cvg143 v144 0 2.773130e-14
Cm143 a144 v144 1.155471e-15
La144 a144 a145 7.221693e-11
Lv144 v144 v145 7.221693e-11
K144 La144 Lv144 0.06
Cag144 a145 0 2.773130e-14
Cvg144 v145 0 2.773130e-14
Cm144 a145 v145 1.155471e-15
La145 a145 a146 7.221693e-11
Lv145 v145 v146 7.221693e-11
K145 La145 Lv145 0.06
Cag145 a146 0 2.773130e-14
Cvg145 v146 0 2.773130e-14
Cm145 a146 v146 1.155471e-15
La146 a146 a147 7.221693e-11
Lv146 v146 v147 7.221693e-11
K146 La146 Lv146 0.06
Cag146 a147 0 2.773130e-14
Cvg146 v147 0 2.773130e-14
Cm146 a147 v147 1.155471e-15
La147 a147 a148 7.221693e-11
Lv147 v147 v148 7.221693e-11
K147 La147 Lv147 0.06
Cag147 a148 0 2.773130e-14
Cvg147 v148 0 2.773130e-14
Cm147 a148 v148 1.155471e-15
La148 a148 a149 7.221693e-11
Lv148 v148 v149 7.221693e-11
K148 La148 Lv148 0.06
Cag148 a149 0 2.773130e-14
Cvg148 v149 0 2.773130e-14
Cm148 a149 v149 1.155471e-15
La149 a149 a150 7.221693e-11
Lv149 v149 v150 7.221693e-11
K149 La149 Lv149 0.06
Cag149 a150 0 2.773130e-14
Cvg149 v150 0 2.773130e-14
Cm149 a150 v150 1.155471e-15
La150 a150 a151 7.221693e-11
Lv150 v150 v151 7.221693e-11
K150 La150 Lv150 0.06
Cag150 a151 0 2.773130e-14
Cvg150 v151 0 2.773130e-14
Cm150 a151 v151 1.155471e-15
La151 a151 a152 7.221693e-11
Lv151 v151 v152 7.221693e-11
K151 La151 Lv151 0.06
Cag151 a152 0 2.773130e-14
Cvg151 v152 0 2.773130e-14
Cm151 a152 v152 1.155471e-15
La152 a152 a153 7.221693e-11
Lv152 v152 v153 7.221693e-11
K152 La152 Lv152 0.06
Cag152 a153 0 2.773130e-14
Cvg152 v153 0 2.773130e-14
Cm152 a153 v153 1.155471e-15
La153 a153 a154 7.221693e-11
Lv153 v153 v154 7.221693e-11
K153 La153 Lv153 0.06
Cag153 a154 0 2.773130e-14
Cvg153 v154 0 2.773130e-14
Cm153 a154 v154 1.155471e-15
La154 a154 a155 7.221693e-11
Lv154 v154 v155 7.221693e-11
K154 La154 Lv154 0.06
Cag154 a155 0 2.773130e-14
Cvg154 v155 0 2.773130e-14
Cm154 a155 v155 1.155471e-15
La155 a155 a156 7.221693e-11
Lv155 v155 v156 7.221693e-11
K155 La155 Lv155 0.06
Cag155 a156 0 2.773130e-14
Cvg155 v156 0 2.773130e-14
Cm155 a156 v156 1.155471e-15
La156 a156 a157 7.221693e-11
Lv156 v156 v157 7.221693e-11
K156 La156 Lv156 0.06
Cag156 a157 0 2.773130e-14
Cvg156 v157 0 2.773130e-14
Cm156 a157 v157 1.155471e-15
La157 a157 a158 7.221693e-11
Lv157 v157 v158 7.221693e-11
K157 La157 Lv157 0.06
Cag157 a158 0 2.773130e-14
Cvg157 v158 0 2.773130e-14
Cm157 a158 v158 1.155471e-15
La158 a158 a159 7.221693e-11
Lv158 v158 v159 7.221693e-11
K158 La158 Lv158 0.06
Cag158 a159 0 2.773130e-14
Cvg158 v159 0 2.773130e-14
Cm158 a159 v159 1.155471e-15
La159 a159 a160 7.221693e-11
Lv159 v159 v160 7.221693e-11
K159 La159 Lv159 0.06
Cag159 a160 0 2.773130e-14
Cvg159 v160 0 2.773130e-14
Cm159 a160 v160 1.155471e-15
La160 a160 a161 7.221693e-11
Lv160 v160 v161 7.221693e-11
K160 La160 Lv160 0.06
Cag160 a161 0 2.773130e-14
Cvg160 v161 0 2.773130e-14
Cm160 a161 v161 1.155471e-15
La161 a161 a162 7.221693e-11
Lv161 v161 v162 7.221693e-11
K161 La161 Lv161 0.06
Cag161 a162 0 2.773130e-14
Cvg161 v162 0 2.773130e-14
Cm161 a162 v162 1.155471e-15
La162 a162 a163 7.221693e-11
Lv162 v162 v163 7.221693e-11
K162 La162 Lv162 0.06
Cag162 a163 0 2.773130e-14
Cvg162 v163 0 2.773130e-14
Cm162 a163 v163 1.155471e-15
La163 a163 a164 7.221693e-11
Lv163 v163 v164 7.221693e-11
K163 La163 Lv163 0.06
Cag163 a164 0 2.773130e-14
Cvg163 v164 0 2.773130e-14
Cm163 a164 v164 1.155471e-15
La164 a164 a165 7.221693e-11
Lv164 v164 v165 7.221693e-11
K164 La164 Lv164 0.06
Cag164 a165 0 2.773130e-14
Cvg164 v165 0 2.773130e-14
Cm164 a165 v165 1.155471e-15
La165 a165 a166 7.221693e-11
Lv165 v165 v166 7.221693e-11
K165 La165 Lv165 0.06
Cag165 a166 0 2.773130e-14
Cvg165 v166 0 2.773130e-14
Cm165 a166 v166 1.155471e-15
La166 a166 a167 7.221693e-11
Lv166 v166 v167 7.221693e-11
K166 La166 Lv166 0.06
Cag166 a167 0 2.773130e-14
Cvg166 v167 0 2.773130e-14
Cm166 a167 v167 1.155471e-15
La167 a167 a168 7.221693e-11
Lv167 v167 v168 7.221693e-11
K167 La167 Lv167 0.06
Cag167 a168 0 2.773130e-14
Cvg167 v168 0 2.773130e-14
Cm167 a168 v168 1.155471e-15
La168 a168 a169 7.221693e-11
Lv168 v168 v169 7.221693e-11
K168 La168 Lv168 0.06
Cag168 a169 0 2.773130e-14
Cvg168 v169 0 2.773130e-14
Cm168 a169 v169 1.155471e-15
La169 a169 a170 7.221693e-11
Lv169 v169 v170 7.221693e-11
K169 La169 Lv169 0.06
Cag169 a170 0 2.773130e-14
Cvg169 v170 0 2.773130e-14
Cm169 a170 v170 1.155471e-15
La170 a170 a171 7.221693e-11
Lv170 v170 v171 7.221693e-11
K170 La170 Lv170 0.06
Cag170 a171 0 2.773130e-14
Cvg170 v171 0 2.773130e-14
Cm170 a171 v171 1.155471e-15
La171 a171 a172 7.221693e-11
Lv171 v171 v172 7.221693e-11
K171 La171 Lv171 0.06
Cag171 a172 0 2.773130e-14
Cvg171 v172 0 2.773130e-14
Cm171 a172 v172 1.155471e-15
La172 a172 a173 7.221693e-11
Lv172 v172 v173 7.221693e-11
K172 La172 Lv172 0.06
Cag172 a173 0 2.773130e-14
Cvg172 v173 0 2.773130e-14
Cm172 a173 v173 1.155471e-15
La173 a173 a174 7.221693e-11
Lv173 v173 v174 7.221693e-11
K173 La173 Lv173 0.06
Cag173 a174 0 2.773130e-14
Cvg173 v174 0 2.773130e-14
Cm173 a174 v174 1.155471e-15
La174 a174 a175 7.221693e-11
Lv174 v174 v175 7.221693e-11
K174 La174 Lv174 0.06
Cag174 a175 0 2.773130e-14
Cvg174 v175 0 2.773130e-14
Cm174 a175 v175 1.155471e-15
La175 a175 a176 7.221693e-11
Lv175 v175 v176 7.221693e-11
K175 La175 Lv175 0.06
Cag175 a176 0 2.773130e-14
Cvg175 v176 0 2.773130e-14
Cm175 a176 v176 1.155471e-15
La176 a176 a177 7.221693e-11
Lv176 v176 v177 7.221693e-11
K176 La176 Lv176 0.06
Cag176 a177 0 2.773130e-14
Cvg176 v177 0 2.773130e-14
Cm176 a177 v177 1.155471e-15
La177 a177 a178 7.221693e-11
Lv177 v177 v178 7.221693e-11
K177 La177 Lv177 0.06
Cag177 a178 0 2.773130e-14
Cvg177 v178 0 2.773130e-14
Cm177 a178 v178 1.155471e-15
La178 a178 a179 7.221693e-11
Lv178 v178 v179 7.221693e-11
K178 La178 Lv178 0.06
Cag178 a179 0 2.773130e-14
Cvg178 v179 0 2.773130e-14
Cm178 a179 v179 1.155471e-15
La179 a179 a180 7.221693e-11
Lv179 v179 v180 7.221693e-11
K179 La179 Lv179 0.06
Cag179 a180 0 2.773130e-14
Cvg179 v180 0 2.773130e-14
Cm179 a180 v180 1.155471e-15
La180 a180 a181 7.221693e-11
Lv180 v180 v181 7.221693e-11
K180 La180 Lv180 0.06
Cag180 a181 0 2.773130e-14
Cvg180 v181 0 2.773130e-14
Cm180 a181 v181 1.155471e-15
La181 a181 a182 7.221693e-11
Lv181 v181 v182 7.221693e-11
K181 La181 Lv181 0.06
Cag181 a182 0 2.773130e-14
Cvg181 v182 0 2.773130e-14
Cm181 a182 v182 1.155471e-15
La182 a182 a183 7.221693e-11
Lv182 v182 v183 7.221693e-11
K182 La182 Lv182 0.06
Cag182 a183 0 2.773130e-14
Cvg182 v183 0 2.773130e-14
Cm182 a183 v183 1.155471e-15
La183 a183 a184 7.221693e-11
Lv183 v183 v184 7.221693e-11
K183 La183 Lv183 0.06
Cag183 a184 0 2.773130e-14
Cvg183 v184 0 2.773130e-14
Cm183 a184 v184 1.155471e-15
La184 a184 a185 7.221693e-11
Lv184 v184 v185 7.221693e-11
K184 La184 Lv184 0.06
Cag184 a185 0 2.773130e-14
Cvg184 v185 0 2.773130e-14
Cm184 a185 v185 1.155471e-15
La185 a185 a186 7.221693e-11
Lv185 v185 v186 7.221693e-11
K185 La185 Lv185 0.06
Cag185 a186 0 2.773130e-14
Cvg185 v186 0 2.773130e-14
Cm185 a186 v186 1.155471e-15
La186 a186 a187 7.221693e-11
Lv186 v186 v187 7.221693e-11
K186 La186 Lv186 0.06
Cag186 a187 0 2.773130e-14
Cvg186 v187 0 2.773130e-14
Cm186 a187 v187 1.155471e-15
La187 a187 a188 7.221693e-11
Lv187 v187 v188 7.221693e-11
K187 La187 Lv187 0.06
Cag187 a188 0 2.773130e-14
Cvg187 v188 0 2.773130e-14
Cm187 a188 v188 1.155471e-15
La188 a188 a189 7.221693e-11
Lv188 v188 v189 7.221693e-11
K188 La188 Lv188 0.06
Cag188 a189 0 2.773130e-14
Cvg188 v189 0 2.773130e-14
Cm188 a189 v189 1.155471e-15
La189 a189 a190 7.221693e-11
Lv189 v189 v190 7.221693e-11
K189 La189 Lv189 0.06
Cag189 a190 0 2.773130e-14
Cvg189 v190 0 2.773130e-14
Cm189 a190 v190 1.155471e-15
La190 a190 a191 7.221693e-11
Lv190 v190 v191 7.221693e-11
K190 La190 Lv190 0.06
Cag190 a191 0 2.773130e-14
Cvg190 v191 0 2.773130e-14
Cm190 a191 v191 1.155471e-15
La191 a191 a192 7.221693e-11
Lv191 v191 v192 7.221693e-11
K191 La191 Lv191 0.06
Cag191 a192 0 2.773130e-14
Cvg191 v192 0 2.773130e-14
Cm191 a192 v192 1.155471e-15
La192 a192 a193 7.221693e-11
Lv192 v192 v193 7.221693e-11
K192 La192 Lv192 0.06
Cag192 a193 0 2.773130e-14
Cvg192 v193 0 2.773130e-14
Cm192 a193 v193 1.155471e-15
La193 a193 a194 7.221693e-11
Lv193 v193 v194 7.221693e-11
K193 La193 Lv193 0.06
Cag193 a194 0 2.773130e-14
Cvg193 v194 0 2.773130e-14
Cm193 a194 v194 1.155471e-15
La194 a194 a195 7.221693e-11
Lv194 v194 v195 7.221693e-11
K194 La194 Lv194 0.06
Cag194 a195 0 2.773130e-14
Cvg194 v195 0 2.773130e-14
Cm194 a195 v195 1.155471e-15
La195 a195 a196 7.221693e-11
Lv195 v195 v196 7.221693e-11
K195 La195 Lv195 0.06
Cag195 a196 0 2.773130e-14
Cvg195 v196 0 2.773130e-14
Cm195 a196 v196 1.155471e-15
La196 a196 a197 7.221693e-11
Lv196 v196 v197 7.221693e-11
K196 La196 Lv196 0.06
Cag196 a197 0 2.773130e-14
Cvg196 v197 0 2.773130e-14
Cm196 a197 v197 1.155471e-15
La197 a197 a198 7.221693e-11
Lv197 v197 v198 7.221693e-11
K197 La197 Lv197 0.06
Cag197 a198 0 2.773130e-14
Cvg197 v198 0 2.773130e-14
Cm197 a198 v198 1.155471e-15
La198 a198 a199 7.221693e-11
Lv198 v198 v199 7.221693e-11
K198 La198 Lv198 0.06
Cag198 a199 0 2.773130e-14
Cvg198 v199 0 2.773130e-14
Cm198 a199 v199 1.155471e-15
La199 a199 a200 7.221693e-11
Lv199 v199 v200 7.221693e-11
K199 La199 Lv199 0.06
Cag199 a200 0 2.773130e-14
Cvg199 v200 0 2.773130e-14
Cm199 a200 v200 1.155471e-15
Raf a200 0 50
Rvf v200 0 50
.control
tran 0.2p 1.2n
linearize v(v200) v(v0) v(a0)
meas tran next find v(v0) at=500p
meas tran fext min v(v200)
meas tran farea integ v(v200) from=0 to=1.15n
print next fext farea
.endc
.end
