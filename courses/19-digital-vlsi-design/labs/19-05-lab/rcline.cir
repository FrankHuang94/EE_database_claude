* Lab 19-05: Example 19-05.3's 1 mm wire (13.3 kOhm, 198 fF) as a 100-section RC ladder
* Circuit A: the bare wire driven by an ideal step. Circuit B: a 1 kOhm driver, the same wire and a 10 fF load.
* 50% delays at the far ends; compare with 0.379 RC = 998 ps (distributed line) and the estimate 1234.4 ps.
* EXPECT ta key:README.md#Lab_19-05.a scale=1e-12 rtol=1e-3
* EXPECT tb key:README.md#Lab_19-05.b scale=1e-12 rtol=1e-3

VIN in 0 PULSE(0 1 0 0.01p 0.01p 1u 2u)
Ra1 in a1 133
Ca1 a1 0 1.98e-15
Ra2 a1 a2 133
Ca2 a2 0 1.98e-15
Ra3 a2 a3 133
Ca3 a3 0 1.98e-15
Ra4 a3 a4 133
Ca4 a4 0 1.98e-15
Ra5 a4 a5 133
Ca5 a5 0 1.98e-15
Ra6 a5 a6 133
Ca6 a6 0 1.98e-15
Ra7 a6 a7 133
Ca7 a7 0 1.98e-15
Ra8 a7 a8 133
Ca8 a8 0 1.98e-15
Ra9 a8 a9 133
Ca9 a9 0 1.98e-15
Ra10 a9 a10 133
Ca10 a10 0 1.98e-15
Ra11 a10 a11 133
Ca11 a11 0 1.98e-15
Ra12 a11 a12 133
Ca12 a12 0 1.98e-15
Ra13 a12 a13 133
Ca13 a13 0 1.98e-15
Ra14 a13 a14 133
Ca14 a14 0 1.98e-15
Ra15 a14 a15 133
Ca15 a15 0 1.98e-15
Ra16 a15 a16 133
Ca16 a16 0 1.98e-15
Ra17 a16 a17 133
Ca17 a17 0 1.98e-15
Ra18 a17 a18 133
Ca18 a18 0 1.98e-15
Ra19 a18 a19 133
Ca19 a19 0 1.98e-15
Ra20 a19 a20 133
Ca20 a20 0 1.98e-15
Ra21 a20 a21 133
Ca21 a21 0 1.98e-15
Ra22 a21 a22 133
Ca22 a22 0 1.98e-15
Ra23 a22 a23 133
Ca23 a23 0 1.98e-15
Ra24 a23 a24 133
Ca24 a24 0 1.98e-15
Ra25 a24 a25 133
Ca25 a25 0 1.98e-15
Ra26 a25 a26 133
Ca26 a26 0 1.98e-15
Ra27 a26 a27 133
Ca27 a27 0 1.98e-15
Ra28 a27 a28 133
Ca28 a28 0 1.98e-15
Ra29 a28 a29 133
Ca29 a29 0 1.98e-15
Ra30 a29 a30 133
Ca30 a30 0 1.98e-15
Ra31 a30 a31 133
Ca31 a31 0 1.98e-15
Ra32 a31 a32 133
Ca32 a32 0 1.98e-15
Ra33 a32 a33 133
Ca33 a33 0 1.98e-15
Ra34 a33 a34 133
Ca34 a34 0 1.98e-15
Ra35 a34 a35 133
Ca35 a35 0 1.98e-15
Ra36 a35 a36 133
Ca36 a36 0 1.98e-15
Ra37 a36 a37 133
Ca37 a37 0 1.98e-15
Ra38 a37 a38 133
Ca38 a38 0 1.98e-15
Ra39 a38 a39 133
Ca39 a39 0 1.98e-15
Ra40 a39 a40 133
Ca40 a40 0 1.98e-15
Ra41 a40 a41 133
Ca41 a41 0 1.98e-15
Ra42 a41 a42 133
Ca42 a42 0 1.98e-15
Ra43 a42 a43 133
Ca43 a43 0 1.98e-15
Ra44 a43 a44 133
Ca44 a44 0 1.98e-15
Ra45 a44 a45 133
Ca45 a45 0 1.98e-15
Ra46 a45 a46 133
Ca46 a46 0 1.98e-15
Ra47 a46 a47 133
Ca47 a47 0 1.98e-15
Ra48 a47 a48 133
Ca48 a48 0 1.98e-15
Ra49 a48 a49 133
Ca49 a49 0 1.98e-15
Ra50 a49 a50 133
Ca50 a50 0 1.98e-15
Ra51 a50 a51 133
Ca51 a51 0 1.98e-15
Ra52 a51 a52 133
Ca52 a52 0 1.98e-15
Ra53 a52 a53 133
Ca53 a53 0 1.98e-15
Ra54 a53 a54 133
Ca54 a54 0 1.98e-15
Ra55 a54 a55 133
Ca55 a55 0 1.98e-15
Ra56 a55 a56 133
Ca56 a56 0 1.98e-15
Ra57 a56 a57 133
Ca57 a57 0 1.98e-15
Ra58 a57 a58 133
Ca58 a58 0 1.98e-15
Ra59 a58 a59 133
Ca59 a59 0 1.98e-15
Ra60 a59 a60 133
Ca60 a60 0 1.98e-15
Ra61 a60 a61 133
Ca61 a61 0 1.98e-15
Ra62 a61 a62 133
Ca62 a62 0 1.98e-15
Ra63 a62 a63 133
Ca63 a63 0 1.98e-15
Ra64 a63 a64 133
Ca64 a64 0 1.98e-15
Ra65 a64 a65 133
Ca65 a65 0 1.98e-15
Ra66 a65 a66 133
Ca66 a66 0 1.98e-15
Ra67 a66 a67 133
Ca67 a67 0 1.98e-15
Ra68 a67 a68 133
Ca68 a68 0 1.98e-15
Ra69 a68 a69 133
Ca69 a69 0 1.98e-15
Ra70 a69 a70 133
Ca70 a70 0 1.98e-15
Ra71 a70 a71 133
Ca71 a71 0 1.98e-15
Ra72 a71 a72 133
Ca72 a72 0 1.98e-15
Ra73 a72 a73 133
Ca73 a73 0 1.98e-15
Ra74 a73 a74 133
Ca74 a74 0 1.98e-15
Ra75 a74 a75 133
Ca75 a75 0 1.98e-15
Ra76 a75 a76 133
Ca76 a76 0 1.98e-15
Ra77 a76 a77 133
Ca77 a77 0 1.98e-15
Ra78 a77 a78 133
Ca78 a78 0 1.98e-15
Ra79 a78 a79 133
Ca79 a79 0 1.98e-15
Ra80 a79 a80 133
Ca80 a80 0 1.98e-15
Ra81 a80 a81 133
Ca81 a81 0 1.98e-15
Ra82 a81 a82 133
Ca82 a82 0 1.98e-15
Ra83 a82 a83 133
Ca83 a83 0 1.98e-15
Ra84 a83 a84 133
Ca84 a84 0 1.98e-15
Ra85 a84 a85 133
Ca85 a85 0 1.98e-15
Ra86 a85 a86 133
Ca86 a86 0 1.98e-15
Ra87 a86 a87 133
Ca87 a87 0 1.98e-15
Ra88 a87 a88 133
Ca88 a88 0 1.98e-15
Ra89 a88 a89 133
Ca89 a89 0 1.98e-15
Ra90 a89 a90 133
Ca90 a90 0 1.98e-15
Ra91 a90 a91 133
Ca91 a91 0 1.98e-15
Ra92 a91 a92 133
Ca92 a92 0 1.98e-15
Ra93 a92 a93 133
Ca93 a93 0 1.98e-15
Ra94 a93 a94 133
Ca94 a94 0 1.98e-15
Ra95 a94 a95 133
Ca95 a95 0 1.98e-15
Ra96 a95 a96 133
Ca96 a96 0 1.98e-15
Ra97 a96 a97 133
Ca97 a97 0 1.98e-15
Ra98 a97 a98 133
Ca98 a98 0 1.98e-15
Ra99 a98 a99 133
Ca99 a99 0 1.98e-15
Ra100 a99 a100 133
Ca100 a100 0 1.98e-15
RDRV in bd 1k
Rb1 bd b1 133
Cb1 b1 0 1.98e-15
Rb2 b1 b2 133
Cb2 b2 0 1.98e-15
Rb3 b2 b3 133
Cb3 b3 0 1.98e-15
Rb4 b3 b4 133
Cb4 b4 0 1.98e-15
Rb5 b4 b5 133
Cb5 b5 0 1.98e-15
Rb6 b5 b6 133
Cb6 b6 0 1.98e-15
Rb7 b6 b7 133
Cb7 b7 0 1.98e-15
Rb8 b7 b8 133
Cb8 b8 0 1.98e-15
Rb9 b8 b9 133
Cb9 b9 0 1.98e-15
Rb10 b9 b10 133
Cb10 b10 0 1.98e-15
Rb11 b10 b11 133
Cb11 b11 0 1.98e-15
Rb12 b11 b12 133
Cb12 b12 0 1.98e-15
Rb13 b12 b13 133
Cb13 b13 0 1.98e-15
Rb14 b13 b14 133
Cb14 b14 0 1.98e-15
Rb15 b14 b15 133
Cb15 b15 0 1.98e-15
Rb16 b15 b16 133
Cb16 b16 0 1.98e-15
Rb17 b16 b17 133
Cb17 b17 0 1.98e-15
Rb18 b17 b18 133
Cb18 b18 0 1.98e-15
Rb19 b18 b19 133
Cb19 b19 0 1.98e-15
Rb20 b19 b20 133
Cb20 b20 0 1.98e-15
Rb21 b20 b21 133
Cb21 b21 0 1.98e-15
Rb22 b21 b22 133
Cb22 b22 0 1.98e-15
Rb23 b22 b23 133
Cb23 b23 0 1.98e-15
Rb24 b23 b24 133
Cb24 b24 0 1.98e-15
Rb25 b24 b25 133
Cb25 b25 0 1.98e-15
Rb26 b25 b26 133
Cb26 b26 0 1.98e-15
Rb27 b26 b27 133
Cb27 b27 0 1.98e-15
Rb28 b27 b28 133
Cb28 b28 0 1.98e-15
Rb29 b28 b29 133
Cb29 b29 0 1.98e-15
Rb30 b29 b30 133
Cb30 b30 0 1.98e-15
Rb31 b30 b31 133
Cb31 b31 0 1.98e-15
Rb32 b31 b32 133
Cb32 b32 0 1.98e-15
Rb33 b32 b33 133
Cb33 b33 0 1.98e-15
Rb34 b33 b34 133
Cb34 b34 0 1.98e-15
Rb35 b34 b35 133
Cb35 b35 0 1.98e-15
Rb36 b35 b36 133
Cb36 b36 0 1.98e-15
Rb37 b36 b37 133
Cb37 b37 0 1.98e-15
Rb38 b37 b38 133
Cb38 b38 0 1.98e-15
Rb39 b38 b39 133
Cb39 b39 0 1.98e-15
Rb40 b39 b40 133
Cb40 b40 0 1.98e-15
Rb41 b40 b41 133
Cb41 b41 0 1.98e-15
Rb42 b41 b42 133
Cb42 b42 0 1.98e-15
Rb43 b42 b43 133
Cb43 b43 0 1.98e-15
Rb44 b43 b44 133
Cb44 b44 0 1.98e-15
Rb45 b44 b45 133
Cb45 b45 0 1.98e-15
Rb46 b45 b46 133
Cb46 b46 0 1.98e-15
Rb47 b46 b47 133
Cb47 b47 0 1.98e-15
Rb48 b47 b48 133
Cb48 b48 0 1.98e-15
Rb49 b48 b49 133
Cb49 b49 0 1.98e-15
Rb50 b49 b50 133
Cb50 b50 0 1.98e-15
Rb51 b50 b51 133
Cb51 b51 0 1.98e-15
Rb52 b51 b52 133
Cb52 b52 0 1.98e-15
Rb53 b52 b53 133
Cb53 b53 0 1.98e-15
Rb54 b53 b54 133
Cb54 b54 0 1.98e-15
Rb55 b54 b55 133
Cb55 b55 0 1.98e-15
Rb56 b55 b56 133
Cb56 b56 0 1.98e-15
Rb57 b56 b57 133
Cb57 b57 0 1.98e-15
Rb58 b57 b58 133
Cb58 b58 0 1.98e-15
Rb59 b58 b59 133
Cb59 b59 0 1.98e-15
Rb60 b59 b60 133
Cb60 b60 0 1.98e-15
Rb61 b60 b61 133
Cb61 b61 0 1.98e-15
Rb62 b61 b62 133
Cb62 b62 0 1.98e-15
Rb63 b62 b63 133
Cb63 b63 0 1.98e-15
Rb64 b63 b64 133
Cb64 b64 0 1.98e-15
Rb65 b64 b65 133
Cb65 b65 0 1.98e-15
Rb66 b65 b66 133
Cb66 b66 0 1.98e-15
Rb67 b66 b67 133
Cb67 b67 0 1.98e-15
Rb68 b67 b68 133
Cb68 b68 0 1.98e-15
Rb69 b68 b69 133
Cb69 b69 0 1.98e-15
Rb70 b69 b70 133
Cb70 b70 0 1.98e-15
Rb71 b70 b71 133
Cb71 b71 0 1.98e-15
Rb72 b71 b72 133
Cb72 b72 0 1.98e-15
Rb73 b72 b73 133
Cb73 b73 0 1.98e-15
Rb74 b73 b74 133
Cb74 b74 0 1.98e-15
Rb75 b74 b75 133
Cb75 b75 0 1.98e-15
Rb76 b75 b76 133
Cb76 b76 0 1.98e-15
Rb77 b76 b77 133
Cb77 b77 0 1.98e-15
Rb78 b77 b78 133
Cb78 b78 0 1.98e-15
Rb79 b78 b79 133
Cb79 b79 0 1.98e-15
Rb80 b79 b80 133
Cb80 b80 0 1.98e-15
Rb81 b80 b81 133
Cb81 b81 0 1.98e-15
Rb82 b81 b82 133
Cb82 b82 0 1.98e-15
Rb83 b82 b83 133
Cb83 b83 0 1.98e-15
Rb84 b83 b84 133
Cb84 b84 0 1.98e-15
Rb85 b84 b85 133
Cb85 b85 0 1.98e-15
Rb86 b85 b86 133
Cb86 b86 0 1.98e-15
Rb87 b86 b87 133
Cb87 b87 0 1.98e-15
Rb88 b87 b88 133
Cb88 b88 0 1.98e-15
Rb89 b88 b89 133
Cb89 b89 0 1.98e-15
Rb90 b89 b90 133
Cb90 b90 0 1.98e-15
Rb91 b90 b91 133
Cb91 b91 0 1.98e-15
Rb92 b91 b92 133
Cb92 b92 0 1.98e-15
Rb93 b92 b93 133
Cb93 b93 0 1.98e-15
Rb94 b93 b94 133
Cb94 b94 0 1.98e-15
Rb95 b94 b95 133
Cb95 b95 0 1.98e-15
Rb96 b95 b96 133
Cb96 b96 0 1.98e-15
Rb97 b96 b97 133
Cb97 b97 0 1.98e-15
Rb98 b97 b98 133
Cb98 b98 0 1.98e-15
Rb99 b98 b99 133
Cb99 b99 0 1.98e-15
Rb100 b99 b100 133
Cb100 b100 0 1.98e-15
CLOAD b100 0 10f

.options reltol=1e-7 abstol=1e-15 vntol=1e-9
.tran 0.5p 6n 0 0.5p
.meas tran ta WHEN v(a100)=0.5 RISE=1
.meas tran tb WHEN v(b100)=0.5 RISE=1
.end
