* Lab 02-06 -- nodal analysis checked in ngspice (DC operating point).
* SPICE builds exactly the G v = i (MNA) system of chapter section 3.10 and solves it by sparse LU.
* Current source convention: "I1 0 n1 DC 10m" pushes 10 mA from ground INTO node n1.
*
* EXPECT v1   key:../../chapters/02-06-vectors-matrices-and-linear-systems.md#Ex_02-06.5b rtol=1e-3
* EXPECT v2   key:../../chapters/02-06-vectors-matrices-and-linear-systems.md#Ex_02-06.5c rtol=1e-3
* EXPECT v3   key:../../chapters/02-06-vectors-matrices-and-linear-systems.md#Ex_02-06.5d rtol=1e-3
* EXPECT ia   key:../../chapters/02-06-vectors-matrices-and-linear-systems.md#Ex_02-06.5e scale=1e-3 rtol=1e-3
* EXPECT va1  key:../../solutions/02-06-solutions.md#02-06.11a rtol=1e-6
* EXPECT va2  key:../../solutions/02-06-solutions.md#02-06.11b rtol=1e-6
* EXPECT vb1  key:../../solutions/02-06-solutions.md#02-06.13a rtol=1e-6
* EXPECT vb2  key:../../solutions/02-06-solutions.md#02-06.13b rtol=1e-6
* EXPECT vc2  key:../../solutions/02-06-solutions.md#02-06.13d rtol=1e-6
* EXPECT iv5  key:../../solutions/02-06-solutions.md#02-06.13e scale=-1e-3 rtol=1e-6

* Example 02-06.5: 10 mA into node 1; Ra 1k (1-2), Rb 2k (1-3), Rc 1k (2-0), Rd 2k (2-3), Re 500 (3-0)
I1  0   n1  DC 10m
Ra  n1  n2  1k
Rb  n1  n3  2k
Rc  n2  0   1k
Rd  n2  n3  2k
Re  n3  0   500

* Problem 02-06.11: 5 mA into a1; R1 2k (a1-0), R2 1k (a1-a2), R3 4k (a2-0); 1 mA drawn out of a2
I2  0   a1  DC 5m
R1  a1  0   2k
R2  a1  a2  1k
R3  a2  0   4k
I3  a2  0   DC 1m

* Problem 02-06.13(b): the resistor triangle with node 3 grounded, 1 mA from node 3 into node 1
I4  0   b1  DC 1m
Rb12 b1 b2  1k
Rb23 b2 0   1k
Rb13 b1 0   2k

* Problem 02-06.13(d): the same triangle driven by a 2 V source (modified nodal analysis)
V5  c1  0   DC 2
Rc12 c1 c2  1k
Rc23 c2 0   1k
Rc13 c1 0   2k

.op
.control
op
let v1 = v(n1)
let v2 = v(n2)
let v3 = v(n3)
let ia = (v(n1) - v(n2))/1k
let va1 = v(a1)
let va2 = v(a2)
let vb1 = v(b1)
let vb2 = v(b2)
let vc2 = v(c2)
let iv5 = i(V5)
echo "v1 = $&v1"
echo "v2 = $&v2"
echo "v3 = $&v3"
echo "ia = $&ia"
echo "va1 = $&va1"
echo "va2 = $&va2"
echo "vb1 = $&vb1"
echo "vb2 = $&vb2"
echo "vc2 = $&vc2"
echo "iv5 = $&iv5"
.endc
.end
