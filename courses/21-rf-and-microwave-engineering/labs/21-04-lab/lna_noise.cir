* Lab 21-04 -- noise figure of four LNA input stages (small-signal models, 290 K, 2.4 GHz).
* Each channel-noise current is generated by a resistor RNx in its own loop (short-circuit current density
* 4kT/RNx through the 0 V source VNx) and mirrored by an F source between drain and source, so the noise has the
* density 4kT x gm with x = gamma/alpha, while the transistor's small-signal current is a noiseless G source.
* Outputs are taken through noiseless controlled sources, so only the source, the channel noise and the named
* resistors contribute. F = (input-referred noise)^2 / (4 k T0 R_s).
*   A: inductively degenerated CS, g_m = 40 mS, f_T = 12 GHz, matched (Example 21-04.2), x = 1
*   B: the same with a gate inductor of Q = 15, re-matched (Example 21-04.3), x = 1
*   C: common-gate stage, g_m = 20 mS, x = 2/3 (Example 21-04.1)
*   D: CG-CS noise-cancelling LNA, g_m1 = 20 mS, R1 = 1 kohm, g_m2 = 100 mS, R2 = 200 ohm, x = 2/3 (Example 21-04.5)
*
* EXPECT nfa key:../../chapters/21-04-low-noise-amplifiers.md#Ex_21-04.2h rtol=2e-3
* EXPECT nfb key:../../chapters/21-04-low-noise-amplifiers.md#Ex_21-04.3f rtol=2e-3
* EXPECT nfc key:../../chapters/21-04-low-noise-amplifiers.md#Ex_21-04.1d rtol=2e-3
* EXPECT nfd key:../../chapters/21-04-low-noise-amplifiers.md#Ex_21-04.5e rtol=2e-3
* EXPECT rina 50 rtol=1e-4
.options temp=16.85 tnom=16.85
* ---- A
VSA sa 0 dc 0 ac 1
RSA sa ina 50
LGA ina ga 7.626174n
CGA ga xa 530.5165f
LSA xa 0 0.6631456n
GMA da xa ga xa 40m
RNA na 0 25
VNA na 0 dc 0
FNA da xa VNA 1
VDA da 0 dc 0
HOA oa 0 VDA 100
* ---- B (r_g = 7.770270 ohm in series with L_g)
VSB sb 0 dc 0 ac 1
RSB sb inb 50
RGB inb lb 7.770270
LGB lb gb 7.729231n
CGB gb xb 530.5165f
LSB xb 0 0.5600892n
GMB db xb gb xb 40m
RNB nb 0 25
VNB nb 0 dc 0
FNB db xb VNB 1
VDB db 0 dc 0
HOB ob 0 VDB 100
* ---- C (gate at ground)
VSC sc 0 dc 0 ac 1
RSC sc xc 50
GMC dc xc 0 xc 20m
RNC nc 0 75
VNC nc 0 dc 0
FNC dc xc VNC 1
VDC dc 0 dc 0
HOC oc 0 VDC 100
* ---- D
VSD sd 0 dc 0 ac 1
RSD sd xd 50
GM1 d1 xd 0 xd 20m
RN1 n1 0 75
VN1 n1 0 dc 0
FN1 d1 xd VN1 1
R1D d1 0 1k
GM2 d2 0 xd 0 100m
RN2 n2 0 15
VN2 n2 0 dc 0
FN2 d2 0 VN2 1
R2D d2 0 200
EOD od 0 d1 d2 1
.control
let k4t = 4 * 1.380649e-23 * 290 * 50
ac lin 1 2.4g 2.4g
let rina = real(v(ina) / (-i(vsa)))
print rina
noise v(oa) VSA lin 1 2.4g 2.4g
let nfa = 10 * log10(inoise_spectrum^2 / k4t)
print nfa
noise v(ob) VSB lin 1 2.4g 2.4g
let nfb = 10 * log10(inoise_spectrum^2 / k4t)
print nfb
noise v(oc) VSC lin 1 2.4g 2.4g
let nfc = 10 * log10(inoise_spectrum^2 / k4t)
print nfc
noise v(od) VSD lin 1 2.4g 2.4g
let nfd = 10 * log10(inoise_spectrum^2 / k4t)
print nfd
.endc
.end
