* Example 01-02.4 and Problem 01-02.9 -- diode operating points that bisection found.
* ngspice solves the same KCL equations with Newton's method. The temperature is set
* to 300 K so that V_T = kT/q = 25.85 mV, as in the chapter.
* Circuit 1: 5 V -> 1 kOhm -> diode (IS = 1e-14 A).
* Circuit 2: 3.3 V -> 10 kOhm -> diode (IS = 1e-15 A).
*
* EXPECT vd1 key:../../chapters/01-02-limits-and-continuity.md#Ex_01-02.4a rtol=2e-4
* EXPECT id1 key:../../chapters/01-02-limits-and-continuity.md#Ex_01-02.4b scale=1e-3 rtol=2e-4
* EXPECT vd2 key:../../solutions/01-02-solutions.md#01-02.9b rtol=2e-4
* EXPECT id2 key:../../solutions/01-02-solutions.md#01-02.9c scale=1e-3 rtol=4e-4

.options temp=26.85 tnom=26.85
V1  in1 0  DC 5
R1  in1 d1 1k
D1  d1  0  dmod1
V2  in2 0  DC 3.3
R2  in2 d2 10k
D2  d2  0  dmod2
.model dmod1 D(IS=1e-14 N=1)
.model dmod2 D(IS=1e-15 N=1)

.control
op
let vd1 = v(d1)
let id1 = -i(V1)
let vd2 = v(d2)
let id2 = -i(V2)
echo "vd1 = $&vd1"
echo "id1 = $&id1"
echo "vd2 = $&vd2"
echo "id2 = $&id2"
.endc
.end
