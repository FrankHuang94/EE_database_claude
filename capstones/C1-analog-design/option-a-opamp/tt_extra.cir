* C1 option A at TT, 27 degC, 1.8 V: CMRR, PSRR+ and input-referred noise. Generated by gen_corners.py.
* EXPECT cmrr key:results.md#A.TT-N.cmrr rtol=1.0e-03
* EXPECT psrr key:results.md#A.TT-N.psrr rtol=1.0e-03
* EXPECT vn1m key:results.md#A.TT-N.vn1m scale=1e-9 rtol=1.0e-03
* EXPECT vtn125 key:results.md#A.TT-N.vtn125 rtol=1.7e-03
* EXPECT vtp125 key:results.md#A.TT-N.vtp125 rtol=1.9e-03
.lib '../models/c1_process.lib' tt
.include opamp.sub

* differential gain
VDD1 vdd1 0 1.8
IR1 vdd1 ib1 20u
VI1 p1 0 DC 0.9 AC 1
X1 p1 n1 o1 vdd1 0 ib1 opamp
L1 o1 n1 1G
C1 n1 0 1
CL1 o1 0 2p
* common-mode gain: the inverting input follows the AC source through 1 F
VDD2 vdd2 0 1.8
IR2 vdd2 ib2 20u
VI2 p2 0 DC 0.9 AC 1
X2 p2 n2 o2 vdd2 0 ib2 opamp
L2 o2 n2 1G
C2 n2 p2 1
CL2 o2 0 2p
* supply gain: AC on VDD
VDD3 vdd3 0 DC 1.8 AC 1
IR3 vdd3 ib3 20u
VI3 p3 0 DC 0.9
X3 p3 n3 o3 vdd3 0 ib3 opamp
L3 o3 n3 1G
C3 n3 0 1
CL3 o3 0 2p
* threshold against temperature: one NMOS and one PMOS with V_SB = 0
VDT dt 0 1.0
VGT gt 0 0.8
MTN dt gt 0 0 nch W=10u L=0.5u
VDTP dtp 0 -1.0
VGTP gtp 0 -0.8
MTP dtp gtp 0 0 pch W=10u L=0.5u

.control
ac dec 20 1 1G
meas ac adm find vdb(o1) at=10
meas ac acm find vdb(o2) at=10
meas ac avdd find vdb(o3) at=10
let cmrr = adm - acm
let psrr = adm - avdd
print cmrr psrr
noise v(o1) vi1 dec 20 1k 100meg
setplot noise1
let vn1m = inoise_spectrum[60]
print vn1m
option temp=125
op
let vtn125 = @mtn[von]
let vtp125 = -@mtp[von]
print vtn125 vtp125
.endc
.end
