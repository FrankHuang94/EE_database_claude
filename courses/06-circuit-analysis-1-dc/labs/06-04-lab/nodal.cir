* Lab 06-04 -- the chapter's nodal and MNA examples, a bridge with a meter, a netlist
* assembled by hand, and a diode solved by Newton's method, all solved by ngspice.
* ngspice builds exactly the modified nodal system of section 3.5 from these lines.
*
* EXPECT ex1v1   key:../../chapters/06-04-nodal-analysis.md#Ex_06-04.1a rtol=1e-6
* EXPECT ex1v2   key:../../chapters/06-04-nodal-analysis.md#Ex_06-04.1b rtol=1e-6
* EXPECT ex2vc   key:../../chapters/06-04-nodal-analysis.md#Ex_06-04.2c rtol=1e-4
* EXPECT ex2vd   key:../../chapters/06-04-nodal-analysis.md#Ex_06-04.2d rtol=1e-4
* EXPECT ex2icd  key:../../chapters/06-04-nodal-analysis.md#Ex_06-04.2e scale=1e-3 rtol=1e-3
* EXPECT ex2i    key:../../chapters/06-04-nodal-analysis.md#Ex_06-04.2f scale=-1 rtol=1e-3
* EXPECT ex3v2   key:../../chapters/06-04-nodal-analysis.md#Ex_06-04.3a rtol=1e-6
* EXPECT ex3v3   key:../../chapters/06-04-nodal-analysis.md#Ex_06-04.3b rtol=1e-6
* EXPECT ex4j1   key:../../chapters/06-04-nodal-analysis.md#Ex_06-04.4a rtol=1e-3
* EXPECT ex4j2   key:../../chapters/06-04-nodal-analysis.md#Ex_06-04.4b rtol=1e-6
* EXPECT p6va    key:../../solutions/06-04-solutions.md#06-04.6a rtol=1e-4
* EXPECT p6vb    key:../../solutions/06-04-solutions.md#06-04.6b rtol=1e-4
* EXPECT p6ig    key:../../solutions/06-04-solutions.md#06-04.6c scale=1e-3 rtol=1e-3
* EXPECT p6i     key:../../solutions/06-04-solutions.md#06-04.6f scale=-1e-3 rtol=1e-3
* EXPECT p7v2    key:../../solutions/06-04-solutions.md#06-04.7a rtol=1e-6
* EXPECT p7j     key:../../solutions/06-04-solutions.md#06-04.7b rtol=1e-6
* EXPECT p13vd   key:../../solutions/06-04-solutions.md#06-04.13e rtol=1e-4
* EXPECT p13id   key:../../solutions/06-04-solutions.md#06-04.13f scale=-1e-3 rtol=1e-3
* EXPECT p15v1  key:../../solutions/06-04-solutions.md#06-04.15a rtol=1e-6
* EXPECT p15vx  key:../../solutions/06-04-solutions.md#06-04.15c rtol=1e-6
* EXPECT p16v2  key:../../solutions/06-04-solutions.md#06-04.16b rtol=5e-4
* EXPECT p16v4  key:../../solutions/06-04-solutions.md#06-04.16d rtol=1e-4
* EXPECT p16i   key:../../solutions/06-04-solutions.md#06-04.16e scale=-1e-3 rtol=1e-4

* Diode at exactly 300 K (V_T = 25.852 mV): nominal and circuit temperature 26.85 C
.options TNOM=26.85
.temp 26.85

* ---- Example 06-04.1: 4 A into node 1, 1 A into node 2 (SPICE: current flows n+ -> source -> n-)
I1a  0 n1a DC 4
I1b  0 n2a DC 1
R1a  n1a 0 2
R2a  n1a n2a 2
R3a  n2a 0 4
* ---- Example 06-04.2: the bridge network of Example 06-03.5, 10 V at node a
V2   a2 0 DC 10
R2ac a2 c2 10
R2ad a2 d2 20
R2cd c2 m2 30
VM2  m2 d2 0
R2cb c2 0 40
R2db d2 0 50
* ---- Examples 06-04.3 and 06-04.4: 12 V grounded, 5 V floating (+ at node 2, - at node 3)
V12  n1c 0 DC 12
V5   n2c n3c DC 5
R12c n1c n2c 2
R13c n1c n3c 3
R2c  n2c 0 4
R3c  n3c 0 6
* ---- Problem 06-04.6: bridge at 5 V with a 100 Ohm galvanometer from B to A
V6   t6 0 DC 5
R61  t6 a6 1k
R62  a6 0 1k
R63  t6 b6 1k
R64  b6 0 1.1k
VM6  b6 g6 0
RG6  g6 a6 100
* ---- Problem 06-04.7: the netlist of the problem, renamed to keep node names unique
V1p  n17 0 DC 10
R1p  n17 n27 2
R2p  n27 0 8
I1p  0 n27 DC 1
* ---- Problem 06-04.13: 5 V, 1 kOhm, diode with IS = 1e-14 A and N = 1
V13  s13 0 DC 5
R13  s13 d13 1k
D13  d13 0 DTEST
.model DTEST D(IS=1e-14 N=1)

* ---- Problem 06-04.15: current source in series with 5k
I15a 0 x15 DC 2m
R15s x15 n151 5k
R15a n151 0 2k
R15b n151 n152 4k
R15c n152 0 4k
I15b 0 n152 DC 2m
* ---- Problem 06-04.16: supernode with four nodes
V16  n161 n162 DC 4
I16a 0 n161 DC 2m
R16a n161 0 2k
R16b n162 0 4k
R16c n162 n163 1k
R16d n163 0 2k
R16e n163 n164 2k
R16f n164 0 1k
I16b 0 n164 DC 1m
.control
op
let ex1v1 = v(n1a)
let ex1v2 = v(n2a)
let ex2vc = v(c2)
let ex2vd = v(d2)
let ex2icd = i(VM2)
let ex2i = i(V2)
let ex3v2 = v(n2c)
let ex3v3 = v(n3c)
let ex4j1 = i(V12)
let ex4j2 = i(V5)
let p6va = v(a6)
let p6vb = v(b6)
let p6ig = i(VM6)
let p6i = i(V6)
let p7v2 = v(n27)
let p7j = i(V1p)
let p13vd = v(d13)
let p13id = i(V13)
echo "ex1v1 = $&ex1v1"
echo "ex1v2 = $&ex1v2"
echo "ex2vc = $&ex2vc"
echo "ex2vd = $&ex2vd"
echo "ex2icd = $&ex2icd"
echo "ex2i = $&ex2i"
echo "ex3v2 = $&ex3v2"
echo "ex3v3 = $&ex3v3"
echo "ex4j1 = $&ex4j1"
echo "ex4j2 = $&ex4j2"
echo "p6va = $&p6va"
echo "p6vb = $&p6vb"
echo "p6ig = $&p6ig"
echo "p6i = $&p6i"
echo "p7v2 = $&p7v2"
echo "p7j = $&p7j"
echo "p13vd = $&p13vd"
echo "p13id = $&p13id"
let p15v1 = v(n151)
let p15vx = v(x15)
let p16v2 = v(n162)
let p16v4 = v(n164)
let p16i = i(V16)
echo "p15v1 = $&p15v1"
echo "p15vx = $&p15vx"
echo "p16v2 = $&p16v2"
echo "p16v4 = $&p16v4"
echo "p16i = $&p16i"
.endc
.end
