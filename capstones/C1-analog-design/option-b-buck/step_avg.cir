* C1 option B: 0.1 -> 0.6 A load step at each input voltage, averaged model. Generated by gen_buck.py.
* EXPECT dev1 key:results.md#B.S.30.nom.dev scale=0.001 rtol=2.2e-03
* EXPECT rec1 key:results.md#B.S.30.nom.rec scale=1e-06 rtol=3.2e-03
* EXPECT dev2 key:results.md#B.S.30.lpcm.dev scale=0.001 rtol=1.9e-03
* EXPECT rec2 key:results.md#B.S.30.lpcm.rec scale=1e-06 rtol=3.5e-03
* EXPECT dev3 key:results.md#B.S.36.nom.dev scale=0.001 rtol=2.4e-03
* EXPECT rec3 key:results.md#B.S.36.nom.rec scale=1e-06 rtol=3.3e-03
* EXPECT dev4 key:results.md#B.S.36.lpcm.dev scale=0.001 rtol=2.2e-03
* EXPECT rec4 key:results.md#B.S.36.lpcm.rec scale=1e-06 rtol=3.5e-03
* EXPECT dev5 key:results.md#B.S.42.nom.dev scale=0.001 rtol=2.7e-03
* EXPECT rec5 key:results.md#B.S.42.nom.rec scale=1e-06 rtol=3.4e-03
* EXPECT dev6 key:results.md#B.S.42.lpcm.dev scale=0.001 rtol=2.4e-03
* EXPECT rec6 key:results.md#B.S.42.lpcm.rec scale=1e-06 rtol=3.6e-03
.include buck_avg.sub

* 3.0 V, L = 1 x 1 uH, C = 1 x 44 uF
Vin1 vin1 0 3.0
X1 vin1 o1 o1 buck_avg params: L=1u C=44u
Il1 o1 0 PULSE(0.1 0.6 200u 100n 100n 1 2)

* 3.0 V, L = 1.2 x 1 uH, C = 0.8 x 44 uF
Vin2 vin2 0 3.0
X2 vin2 o2 o2 buck_avg params: L=1.2u C=35.2u
Il2 o2 0 PULSE(0.1 0.6 200u 100n 100n 1 2)

* 3.6 V, L = 1 x 1 uH, C = 1 x 44 uF
Vin3 vin3 0 3.6
X3 vin3 o3 o3 buck_avg params: L=1u C=44u
Il3 o3 0 PULSE(0.1 0.6 200u 100n 100n 1 2)

* 3.6 V, L = 1.2 x 1 uH, C = 0.8 x 44 uF
Vin4 vin4 0 3.6
X4 vin4 o4 o4 buck_avg params: L=1.2u C=35.2u
Il4 o4 0 PULSE(0.1 0.6 200u 100n 100n 1 2)

* 4.2 V, L = 1 x 1 uH, C = 1 x 44 uF
Vin5 vin5 0 4.2
X5 vin5 o5 o5 buck_avg params: L=1u C=44u
Il5 o5 0 PULSE(0.1 0.6 200u 100n 100n 1 2)

* 4.2 V, L = 1.2 x 1 uH, C = 0.8 x 44 uF
Vin6 vin6 0 4.2
X6 vin6 o6 o6 buck_avg params: L=1.2u C=35.2u
Il6 o6 0 PULSE(0.1 0.6 200u 100n 100n 1 2)

.control
tran 20n 400u
meas tran vp1 find v(o1) at=199u
meas tran vm1 min v(o1) from=200u to=300u
meas tran tr1 when v(o1)=1.188 rise=1 from=200u
let dev1 = vp1 - vm1
let rec1 = tr1 - 200u
print dev1 rec1
meas tran vp2 find v(o2) at=199u
meas tran vm2 min v(o2) from=200u to=300u
meas tran tr2 when v(o2)=1.188 rise=1 from=200u
let dev2 = vp2 - vm2
let rec2 = tr2 - 200u
print dev2 rec2
meas tran vp3 find v(o3) at=199u
meas tran vm3 min v(o3) from=200u to=300u
meas tran tr3 when v(o3)=1.188 rise=1 from=200u
let dev3 = vp3 - vm3
let rec3 = tr3 - 200u
print dev3 rec3
meas tran vp4 find v(o4) at=199u
meas tran vm4 min v(o4) from=200u to=300u
meas tran tr4 when v(o4)=1.188 rise=1 from=200u
let dev4 = vp4 - vm4
let rec4 = tr4 - 200u
print dev4 rec4
meas tran vp5 find v(o5) at=199u
meas tran vm5 min v(o5) from=200u to=300u
meas tran tr5 when v(o5)=1.188 rise=1 from=200u
let dev5 = vp5 - vm5
let rec5 = tr5 - 200u
print dev5 rec5
meas tran vp6 find v(o6) at=199u
meas tran vm6 min v(o6) from=200u to=300u
meas tran tr6 when v(o6)=1.188 rise=1 from=200u
let dev6 = vp6 - vm6
let rec6 = tr6 - 200u
print dev6 rec6
.endc
.end
