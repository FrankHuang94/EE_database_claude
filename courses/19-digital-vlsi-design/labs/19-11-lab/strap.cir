* Lab 19-11: IR drop on a strap fed at both ends (Problem 19-11.12)
* 200 um strap, r = 0.5 ohm/um, split into 200 segments of 1 um; a uniform 1 mA load drawn as 5 uA at every
* interior node (the trapezoidal share), plus a 2 mA point load at 50 um. The supply is 1.8 V at both ends.
* The node voltages of this ladder equal the continuous strap's exactly (pnr.strap_drop_ladder).
* EXPECT drop50 key:../../solutions/19-11-solutions.md#19-11.12b scale=1e-3 rtol=1e-3
* EXPECT drop100 key:README.md#Lab_19-11.a scale=1e-3 rtol=1e-3
VDD n0 0 DC 1.8
VDD2 n200 0 DC 1.8
R1 n0 n1 0.5
R2 n1 n2 0.5
R3 n2 n3 0.5
R4 n3 n4 0.5
R5 n4 n5 0.5
R6 n5 n6 0.5
R7 n6 n7 0.5
R8 n7 n8 0.5
R9 n8 n9 0.5
R10 n9 n10 0.5
R11 n10 n11 0.5
R12 n11 n12 0.5
R13 n12 n13 0.5
R14 n13 n14 0.5
R15 n14 n15 0.5
R16 n15 n16 0.5
R17 n16 n17 0.5
R18 n17 n18 0.5
R19 n18 n19 0.5
R20 n19 n20 0.5
R21 n20 n21 0.5
R22 n21 n22 0.5
R23 n22 n23 0.5
R24 n23 n24 0.5
R25 n24 n25 0.5
R26 n25 n26 0.5
R27 n26 n27 0.5
R28 n27 n28 0.5
R29 n28 n29 0.5
R30 n29 n30 0.5
R31 n30 n31 0.5
R32 n31 n32 0.5
R33 n32 n33 0.5
R34 n33 n34 0.5
R35 n34 n35 0.5
R36 n35 n36 0.5
R37 n36 n37 0.5
R38 n37 n38 0.5
R39 n38 n39 0.5
R40 n39 n40 0.5
R41 n40 n41 0.5
R42 n41 n42 0.5
R43 n42 n43 0.5
R44 n43 n44 0.5
R45 n44 n45 0.5
R46 n45 n46 0.5
R47 n46 n47 0.5
R48 n47 n48 0.5
R49 n48 n49 0.5
R50 n49 n50 0.5
R51 n50 n51 0.5
R52 n51 n52 0.5
R53 n52 n53 0.5
R54 n53 n54 0.5
R55 n54 n55 0.5
R56 n55 n56 0.5
R57 n56 n57 0.5
R58 n57 n58 0.5
R59 n58 n59 0.5
R60 n59 n60 0.5
R61 n60 n61 0.5
R62 n61 n62 0.5
R63 n62 n63 0.5
R64 n63 n64 0.5
R65 n64 n65 0.5
R66 n65 n66 0.5
R67 n66 n67 0.5
R68 n67 n68 0.5
R69 n68 n69 0.5
R70 n69 n70 0.5
R71 n70 n71 0.5
R72 n71 n72 0.5
R73 n72 n73 0.5
R74 n73 n74 0.5
R75 n74 n75 0.5
R76 n75 n76 0.5
R77 n76 n77 0.5
R78 n77 n78 0.5
R79 n78 n79 0.5
R80 n79 n80 0.5
R81 n80 n81 0.5
R82 n81 n82 0.5
R83 n82 n83 0.5
R84 n83 n84 0.5
R85 n84 n85 0.5
R86 n85 n86 0.5
R87 n86 n87 0.5
R88 n87 n88 0.5
R89 n88 n89 0.5
R90 n89 n90 0.5
R91 n90 n91 0.5
R92 n91 n92 0.5
R93 n92 n93 0.5
R94 n93 n94 0.5
R95 n94 n95 0.5
R96 n95 n96 0.5
R97 n96 n97 0.5
R98 n97 n98 0.5
R99 n98 n99 0.5
R100 n99 n100 0.5
R101 n100 n101 0.5
R102 n101 n102 0.5
R103 n102 n103 0.5
R104 n103 n104 0.5
R105 n104 n105 0.5
R106 n105 n106 0.5
R107 n106 n107 0.5
R108 n107 n108 0.5
R109 n108 n109 0.5
R110 n109 n110 0.5
R111 n110 n111 0.5
R112 n111 n112 0.5
R113 n112 n113 0.5
R114 n113 n114 0.5
R115 n114 n115 0.5
R116 n115 n116 0.5
R117 n116 n117 0.5
R118 n117 n118 0.5
R119 n118 n119 0.5
R120 n119 n120 0.5
R121 n120 n121 0.5
R122 n121 n122 0.5
R123 n122 n123 0.5
R124 n123 n124 0.5
R125 n124 n125 0.5
R126 n125 n126 0.5
R127 n126 n127 0.5
R128 n127 n128 0.5
R129 n128 n129 0.5
R130 n129 n130 0.5
R131 n130 n131 0.5
R132 n131 n132 0.5
R133 n132 n133 0.5
R134 n133 n134 0.5
R135 n134 n135 0.5
R136 n135 n136 0.5
R137 n136 n137 0.5
R138 n137 n138 0.5
R139 n138 n139 0.5
R140 n139 n140 0.5
R141 n140 n141 0.5
R142 n141 n142 0.5
R143 n142 n143 0.5
R144 n143 n144 0.5
R145 n144 n145 0.5
R146 n145 n146 0.5
R147 n146 n147 0.5
R148 n147 n148 0.5
R149 n148 n149 0.5
R150 n149 n150 0.5
R151 n150 n151 0.5
R152 n151 n152 0.5
R153 n152 n153 0.5
R154 n153 n154 0.5
R155 n154 n155 0.5
R156 n155 n156 0.5
R157 n156 n157 0.5
R158 n157 n158 0.5
R159 n158 n159 0.5
R160 n159 n160 0.5
R161 n160 n161 0.5
R162 n161 n162 0.5
R163 n162 n163 0.5
R164 n163 n164 0.5
R165 n164 n165 0.5
R166 n165 n166 0.5
R167 n166 n167 0.5
R168 n167 n168 0.5
R169 n168 n169 0.5
R170 n169 n170 0.5
R171 n170 n171 0.5
R172 n171 n172 0.5
R173 n172 n173 0.5
R174 n173 n174 0.5
R175 n174 n175 0.5
R176 n175 n176 0.5
R177 n176 n177 0.5
R178 n177 n178 0.5
R179 n178 n179 0.5
R180 n179 n180 0.5
R181 n180 n181 0.5
R182 n181 n182 0.5
R183 n182 n183 0.5
R184 n183 n184 0.5
R185 n184 n185 0.5
R186 n185 n186 0.5
R187 n186 n187 0.5
R188 n187 n188 0.5
R189 n188 n189 0.5
R190 n189 n190 0.5
R191 n190 n191 0.5
R192 n191 n192 0.5
R193 n192 n193 0.5
R194 n193 n194 0.5
R195 n194 n195 0.5
R196 n195 n196 0.5
R197 n196 n197 0.5
R198 n197 n198 0.5
R199 n198 n199 0.5
R200 n199 n200 0.5
I1 n1 0 DC 5e-06
I2 n2 0 DC 5e-06
I3 n3 0 DC 5e-06
I4 n4 0 DC 5e-06
I5 n5 0 DC 5e-06
I6 n6 0 DC 5e-06
I7 n7 0 DC 5e-06
I8 n8 0 DC 5e-06
I9 n9 0 DC 5e-06
I10 n10 0 DC 5e-06
I11 n11 0 DC 5e-06
I12 n12 0 DC 5e-06
I13 n13 0 DC 5e-06
I14 n14 0 DC 5e-06
I15 n15 0 DC 5e-06
I16 n16 0 DC 5e-06
I17 n17 0 DC 5e-06
I18 n18 0 DC 5e-06
I19 n19 0 DC 5e-06
I20 n20 0 DC 5e-06
I21 n21 0 DC 5e-06
I22 n22 0 DC 5e-06
I23 n23 0 DC 5e-06
I24 n24 0 DC 5e-06
I25 n25 0 DC 5e-06
I26 n26 0 DC 5e-06
I27 n27 0 DC 5e-06
I28 n28 0 DC 5e-06
I29 n29 0 DC 5e-06
I30 n30 0 DC 5e-06
I31 n31 0 DC 5e-06
I32 n32 0 DC 5e-06
I33 n33 0 DC 5e-06
I34 n34 0 DC 5e-06
I35 n35 0 DC 5e-06
I36 n36 0 DC 5e-06
I37 n37 0 DC 5e-06
I38 n38 0 DC 5e-06
I39 n39 0 DC 5e-06
I40 n40 0 DC 5e-06
I41 n41 0 DC 5e-06
I42 n42 0 DC 5e-06
I43 n43 0 DC 5e-06
I44 n44 0 DC 5e-06
I45 n45 0 DC 5e-06
I46 n46 0 DC 5e-06
I47 n47 0 DC 5e-06
I48 n48 0 DC 5e-06
I49 n49 0 DC 5e-06
I50 n50 0 DC 0.002005
I51 n51 0 DC 5e-06
I52 n52 0 DC 5e-06
I53 n53 0 DC 5e-06
I54 n54 0 DC 5e-06
I55 n55 0 DC 5e-06
I56 n56 0 DC 5e-06
I57 n57 0 DC 5e-06
I58 n58 0 DC 5e-06
I59 n59 0 DC 5e-06
I60 n60 0 DC 5e-06
I61 n61 0 DC 5e-06
I62 n62 0 DC 5e-06
I63 n63 0 DC 5e-06
I64 n64 0 DC 5e-06
I65 n65 0 DC 5e-06
I66 n66 0 DC 5e-06
I67 n67 0 DC 5e-06
I68 n68 0 DC 5e-06
I69 n69 0 DC 5e-06
I70 n70 0 DC 5e-06
I71 n71 0 DC 5e-06
I72 n72 0 DC 5e-06
I73 n73 0 DC 5e-06
I74 n74 0 DC 5e-06
I75 n75 0 DC 5e-06
I76 n76 0 DC 5e-06
I77 n77 0 DC 5e-06
I78 n78 0 DC 5e-06
I79 n79 0 DC 5e-06
I80 n80 0 DC 5e-06
I81 n81 0 DC 5e-06
I82 n82 0 DC 5e-06
I83 n83 0 DC 5e-06
I84 n84 0 DC 5e-06
I85 n85 0 DC 5e-06
I86 n86 0 DC 5e-06
I87 n87 0 DC 5e-06
I88 n88 0 DC 5e-06
I89 n89 0 DC 5e-06
I90 n90 0 DC 5e-06
I91 n91 0 DC 5e-06
I92 n92 0 DC 5e-06
I93 n93 0 DC 5e-06
I94 n94 0 DC 5e-06
I95 n95 0 DC 5e-06
I96 n96 0 DC 5e-06
I97 n97 0 DC 5e-06
I98 n98 0 DC 5e-06
I99 n99 0 DC 5e-06
I100 n100 0 DC 5e-06
I101 n101 0 DC 5e-06
I102 n102 0 DC 5e-06
I103 n103 0 DC 5e-06
I104 n104 0 DC 5e-06
I105 n105 0 DC 5e-06
I106 n106 0 DC 5e-06
I107 n107 0 DC 5e-06
I108 n108 0 DC 5e-06
I109 n109 0 DC 5e-06
I110 n110 0 DC 5e-06
I111 n111 0 DC 5e-06
I112 n112 0 DC 5e-06
I113 n113 0 DC 5e-06
I114 n114 0 DC 5e-06
I115 n115 0 DC 5e-06
I116 n116 0 DC 5e-06
I117 n117 0 DC 5e-06
I118 n118 0 DC 5e-06
I119 n119 0 DC 5e-06
I120 n120 0 DC 5e-06
I121 n121 0 DC 5e-06
I122 n122 0 DC 5e-06
I123 n123 0 DC 5e-06
I124 n124 0 DC 5e-06
I125 n125 0 DC 5e-06
I126 n126 0 DC 5e-06
I127 n127 0 DC 5e-06
I128 n128 0 DC 5e-06
I129 n129 0 DC 5e-06
I130 n130 0 DC 5e-06
I131 n131 0 DC 5e-06
I132 n132 0 DC 5e-06
I133 n133 0 DC 5e-06
I134 n134 0 DC 5e-06
I135 n135 0 DC 5e-06
I136 n136 0 DC 5e-06
I137 n137 0 DC 5e-06
I138 n138 0 DC 5e-06
I139 n139 0 DC 5e-06
I140 n140 0 DC 5e-06
I141 n141 0 DC 5e-06
I142 n142 0 DC 5e-06
I143 n143 0 DC 5e-06
I144 n144 0 DC 5e-06
I145 n145 0 DC 5e-06
I146 n146 0 DC 5e-06
I147 n147 0 DC 5e-06
I148 n148 0 DC 5e-06
I149 n149 0 DC 5e-06
I150 n150 0 DC 5e-06
I151 n151 0 DC 5e-06
I152 n152 0 DC 5e-06
I153 n153 0 DC 5e-06
I154 n154 0 DC 5e-06
I155 n155 0 DC 5e-06
I156 n156 0 DC 5e-06
I157 n157 0 DC 5e-06
I158 n158 0 DC 5e-06
I159 n159 0 DC 5e-06
I160 n160 0 DC 5e-06
I161 n161 0 DC 5e-06
I162 n162 0 DC 5e-06
I163 n163 0 DC 5e-06
I164 n164 0 DC 5e-06
I165 n165 0 DC 5e-06
I166 n166 0 DC 5e-06
I167 n167 0 DC 5e-06
I168 n168 0 DC 5e-06
I169 n169 0 DC 5e-06
I170 n170 0 DC 5e-06
I171 n171 0 DC 5e-06
I172 n172 0 DC 5e-06
I173 n173 0 DC 5e-06
I174 n174 0 DC 5e-06
I175 n175 0 DC 5e-06
I176 n176 0 DC 5e-06
I177 n177 0 DC 5e-06
I178 n178 0 DC 5e-06
I179 n179 0 DC 5e-06
I180 n180 0 DC 5e-06
I181 n181 0 DC 5e-06
I182 n182 0 DC 5e-06
I183 n183 0 DC 5e-06
I184 n184 0 DC 5e-06
I185 n185 0 DC 5e-06
I186 n186 0 DC 5e-06
I187 n187 0 DC 5e-06
I188 n188 0 DC 5e-06
I189 n189 0 DC 5e-06
I190 n190 0 DC 5e-06
I191 n191 0 DC 5e-06
I192 n192 0 DC 5e-06
I193 n193 0 DC 5e-06
I194 n194 0 DC 5e-06
I195 n195 0 DC 5e-06
I196 n196 0 DC 5e-06
I197 n197 0 DC 5e-06
I198 n198 0 DC 5e-06
I199 n199 0 DC 5e-06
.control
op
let drop50 = 1.8 - v(n50)
let drop100 = 1.8 - v(n100)
echo "drop50 = $&drop50"
echo "drop100 = $&drop100"
.endc
.end
