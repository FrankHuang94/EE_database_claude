* Lab 21-10: beam squint of a 16-element receive array, phase shifters vs true-time delay (Example 21-10.4)
* Elements spaced lambda/2 at 28 GHz, beam steered to 60 degrees. Path k carries the free-space delay
* (N-1-k)*tg (tg = d sin(theta0)/c) as a matched 50 ohm line. Phase-shifter array: each element's fixed
* phase -360*f0*k*tg is set at 28 GHz and does not change with frequency. TTD array: a second line of delay
* k*tg equalizes every path at all frequencies. VCCS sum the 16 line outputs into 1 ohm.
* Generated by gen_squint.py; tg = 1.546474e-11 s.
* EXPECT lps26 key:../../chapters/21-10-antennas-arrays-mmwave.md#Ex_21-10.4e rtol=2e-3
* EXPECT lps30 key:../../chapters/21-10-antennas-arrays-mmwave.md#Ex_21-10.4e rtol=2e-3
* EXPECT gttd26 key:../../chapters/21-10-antennas-arrays-mmwave.md#Ex_21-10.4g rtol=1e-3

Vps0 sps0 0 dc 0 ac 1 0.000000
Rpss0 sps0 aps0 50
Tps0 aps0 0 eps0 0 Z0=50 TD=2.319710903e-10
Rpsl0 eps0 0 50
Gps0 0 outps eps0 0 1
Vps1 sps1 0 dc 0 ac 1 -155.884573
Rpss1 sps1 aps1 50
Tps1 aps1 0 eps1 0 Z0=50 TD=2.165063509e-10
Rpsl1 eps1 0 50
Gps1 0 outps eps1 0 1
Vps2 sps2 0 dc 0 ac 1 48.230855
Rpss2 sps2 aps2 50
Tps2 aps2 0 eps2 0 Z0=50 TD=2.010416116e-10
Rpsl2 eps2 0 50
Gps2 0 outps eps2 0 1
Vps3 sps3 0 dc 0 ac 1 -107.653718
Rpss3 sps3 aps3 50
Tps3 aps3 0 eps3 0 Z0=50 TD=1.855768722e-10
Rpsl3 eps3 0 50
Gps3 0 outps eps3 0 1
Vps4 sps4 0 dc 0 ac 1 96.461709
Rpss4 sps4 aps4 50
Tps4 aps4 0 eps4 0 Z0=50 TD=1.701121329e-10
Rpsl4 eps4 0 50
Gps4 0 outps eps4 0 1
Vps5 sps5 0 dc 0 ac 1 -59.422863
Rpss5 sps5 aps5 50
Tps5 aps5 0 eps5 0 Z0=50 TD=1.546473935e-10
Rpsl5 eps5 0 50
Gps5 0 outps eps5 0 1
Vps6 sps6 0 dc 0 ac 1 144.692564
Rpss6 sps6 aps6 50
Tps6 aps6 0 eps6 0 Z0=50 TD=1.391826542e-10
Rpsl6 eps6 0 50
Gps6 0 outps eps6 0 1
Vps7 sps7 0 dc 0 ac 1 -11.192009
Rpss7 sps7 aps7 50
Tps7 aps7 0 eps7 0 Z0=50 TD=1.237179148e-10
Rpsl7 eps7 0 50
Gps7 0 outps eps7 0 1
Vps8 sps8 0 dc 0 ac 1 -167.076581
Rpss8 sps8 aps8 50
Tps8 aps8 0 eps8 0 Z0=50 TD=1.082531755e-10
Rpsl8 eps8 0 50
Gps8 0 outps eps8 0 1
Vps9 sps9 0 dc 0 ac 1 37.038846
Rpss9 sps9 aps9 50
Tps9 aps9 0 eps9 0 Z0=50 TD=9.278843612e-11
Rpsl9 eps9 0 50
Gps9 0 outps eps9 0 1
Vps10 sps10 0 dc 0 ac 1 -118.845727
Rpss10 sps10 aps10 50
Tps10 aps10 0 eps10 0 Z0=50 TD=7.732369677e-11
Rpsl10 eps10 0 50
Gps10 0 outps eps10 0 1
Vps11 sps11 0 dc 0 ac 1 85.269701
Rpss11 sps11 aps11 50
Tps11 aps11 0 eps11 0 Z0=50 TD=6.185895741e-11
Rpsl11 eps11 0 50
Gps11 0 outps eps11 0 1
Vps12 sps12 0 dc 0 ac 1 -70.614872
Rpss12 sps12 aps12 50
Tps12 aps12 0 eps12 0 Z0=50 TD=4.639421806e-11
Rpsl12 eps12 0 50
Gps12 0 outps eps12 0 1
Vps13 sps13 0 dc 0 ac 1 133.500555
Rpss13 sps13 aps13 50
Tps13 aps13 0 eps13 0 Z0=50 TD=3.092947871e-11
Rpsl13 eps13 0 50
Gps13 0 outps eps13 0 1
Vps14 sps14 0 dc 0 ac 1 -22.384018
Rpss14 sps14 aps14 50
Tps14 aps14 0 eps14 0 Z0=50 TD=1.546473935e-11
Rpsl14 eps14 0 50
Gps14 0 outps eps14 0 1
Vps15 sps15 0 dc 0 ac 1 -178.268590
Rpss15 sps15 aps15 50
Rpsw15 aps15 eps15 1e-6
Rpsl15 eps15 0 50
Gps15 0 outps eps15 0 1
Routps outps 0 1

Vttd0 sttd0 0 dc 0 ac 1 0.000000
Rttds0 sttd0 attd0 50
Tttd0 attd0 0 mttd0 0 Z0=50 TD=2.319710903e-10
Rttdc0 mttd0 ettd0 1e-6
Rttdl0 ettd0 0 50
Gttd0 0 outttd ettd0 0 1
Vttd1 sttd1 0 dc 0 ac 1 0.000000
Rttds1 sttd1 attd1 50
Tttd1 attd1 0 mttd1 0 Z0=50 TD=2.165063509e-10
Tttdc1 mttd1 0 ettd1 0 Z0=50 TD=1.546473935e-11
Rttdl1 ettd1 0 50
Gttd1 0 outttd ettd1 0 1
Vttd2 sttd2 0 dc 0 ac 1 0.000000
Rttds2 sttd2 attd2 50
Tttd2 attd2 0 mttd2 0 Z0=50 TD=2.010416116e-10
Tttdc2 mttd2 0 ettd2 0 Z0=50 TD=3.092947871e-11
Rttdl2 ettd2 0 50
Gttd2 0 outttd ettd2 0 1
Vttd3 sttd3 0 dc 0 ac 1 0.000000
Rttds3 sttd3 attd3 50
Tttd3 attd3 0 mttd3 0 Z0=50 TD=1.855768722e-10
Tttdc3 mttd3 0 ettd3 0 Z0=50 TD=4.639421806e-11
Rttdl3 ettd3 0 50
Gttd3 0 outttd ettd3 0 1
Vttd4 sttd4 0 dc 0 ac 1 0.000000
Rttds4 sttd4 attd4 50
Tttd4 attd4 0 mttd4 0 Z0=50 TD=1.701121329e-10
Tttdc4 mttd4 0 ettd4 0 Z0=50 TD=6.185895741e-11
Rttdl4 ettd4 0 50
Gttd4 0 outttd ettd4 0 1
Vttd5 sttd5 0 dc 0 ac 1 0.000000
Rttds5 sttd5 attd5 50
Tttd5 attd5 0 mttd5 0 Z0=50 TD=1.546473935e-10
Tttdc5 mttd5 0 ettd5 0 Z0=50 TD=7.732369677e-11
Rttdl5 ettd5 0 50
Gttd5 0 outttd ettd5 0 1
Vttd6 sttd6 0 dc 0 ac 1 0.000000
Rttds6 sttd6 attd6 50
Tttd6 attd6 0 mttd6 0 Z0=50 TD=1.391826542e-10
Tttdc6 mttd6 0 ettd6 0 Z0=50 TD=9.278843612e-11
Rttdl6 ettd6 0 50
Gttd6 0 outttd ettd6 0 1
Vttd7 sttd7 0 dc 0 ac 1 0.000000
Rttds7 sttd7 attd7 50
Tttd7 attd7 0 mttd7 0 Z0=50 TD=1.237179148e-10
Tttdc7 mttd7 0 ettd7 0 Z0=50 TD=1.082531755e-10
Rttdl7 ettd7 0 50
Gttd7 0 outttd ettd7 0 1
Vttd8 sttd8 0 dc 0 ac 1 0.000000
Rttds8 sttd8 attd8 50
Tttd8 attd8 0 mttd8 0 Z0=50 TD=1.082531755e-10
Tttdc8 mttd8 0 ettd8 0 Z0=50 TD=1.237179148e-10
Rttdl8 ettd8 0 50
Gttd8 0 outttd ettd8 0 1
Vttd9 sttd9 0 dc 0 ac 1 0.000000
Rttds9 sttd9 attd9 50
Tttd9 attd9 0 mttd9 0 Z0=50 TD=9.278843612e-11
Tttdc9 mttd9 0 ettd9 0 Z0=50 TD=1.391826542e-10
Rttdl9 ettd9 0 50
Gttd9 0 outttd ettd9 0 1
Vttd10 sttd10 0 dc 0 ac 1 0.000000
Rttds10 sttd10 attd10 50
Tttd10 attd10 0 mttd10 0 Z0=50 TD=7.732369677e-11
Tttdc10 mttd10 0 ettd10 0 Z0=50 TD=1.546473935e-10
Rttdl10 ettd10 0 50
Gttd10 0 outttd ettd10 0 1
Vttd11 sttd11 0 dc 0 ac 1 0.000000
Rttds11 sttd11 attd11 50
Tttd11 attd11 0 mttd11 0 Z0=50 TD=6.185895741e-11
Tttdc11 mttd11 0 ettd11 0 Z0=50 TD=1.701121329e-10
Rttdl11 ettd11 0 50
Gttd11 0 outttd ettd11 0 1
Vttd12 sttd12 0 dc 0 ac 1 0.000000
Rttds12 sttd12 attd12 50
Tttd12 attd12 0 mttd12 0 Z0=50 TD=4.639421806e-11
Tttdc12 mttd12 0 ettd12 0 Z0=50 TD=1.855768722e-10
Rttdl12 ettd12 0 50
Gttd12 0 outttd ettd12 0 1
Vttd13 sttd13 0 dc 0 ac 1 0.000000
Rttds13 sttd13 attd13 50
Tttd13 attd13 0 mttd13 0 Z0=50 TD=3.092947871e-11
Tttdc13 mttd13 0 ettd13 0 Z0=50 TD=2.010416116e-10
Rttdl13 ettd13 0 50
Gttd13 0 outttd ettd13 0 1
Vttd14 sttd14 0 dc 0 ac 1 0.000000
Rttds14 sttd14 attd14 50
Tttd14 attd14 0 mttd14 0 Z0=50 TD=1.546473935e-11
Tttdc14 mttd14 0 ettd14 0 Z0=50 TD=2.165063509e-10
Rttdl14 ettd14 0 50
Gttd14 0 outttd ettd14 0 1
Vttd15 sttd15 0 dc 0 ac 1 0.000000
Rttds15 sttd15 attd15 50
Rttdw15 attd15 mttd15 1e-6
Tttdc15 mttd15 0 ettd15 0 Z0=50 TD=2.319710903e-10
Rttdl15 ettd15 0 50
Gttd15 0 outttd ettd15 0 1
Routttd outttd 0 1

.control
ac lin 5 26G 30G
let lps = db(v(outps)) - db(v(outttd))
let gttd = db(v(outttd)/0.5)
meas ac lps26 find lps at=26e9
meas ac lps28 find lps at=28e9
meas ac lps30 find lps at=30e9
meas ac gttd26 find gttd at=26e9
meas ac gttd30 find gttd at=30e9
.endc
.end
