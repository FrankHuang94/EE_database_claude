* C1 option B: 0.1 -> 0.6 A load step at 3.0 V, L +20%, C -20%, switching model (12 ohm base load plus a 0.5 A step). Generated by gen_buck.py.
* EXPECT dev key:results.md#B.W.30.lpcm.dev scale=0.001 rtol=1.8e-03
* EXPECT rec key:results.md#B.W.30.lpcm.rec scale=1e-06 rtol=2.9e-03
.include buck_sw.sub
Vramp ramp 0 PULSE(0 1 0 498n 2n 0 500n)
.options reltol=1e-4

Vin1 vin1 0 3.0
X1 vin1 o1 o1 ramp buck_sw params: L=1.2u C=35.2u
Rl1 o1 0 12
Il1 o1 0 PULSE(0 0.5 250u 100n 100n 1 2)

.control
tran 1n 350u 0 2n uic
meas tran vp avg v(o1) from=245u to=250u
meas tran vm min v(o1) from=250u to=300u
meas tran tr when v(o1)=1.188 rise=1 from=250u
let dev = vp - vm
let rec = tr - 250u
print dev rec
.endc
.end
