* Lab 23-06: incremental-step pulse programming (ISPP) of a NAND cell with Fowler-Nordheim tunneling
* Control-gate coupling C_CG = 16 aF, tunnel-oxide capacitance C_TOX = 12.33 aF (50 nm x 50 nm, 7 nm SiO2).
* Electrons tunnel from the channel (0 V) into the floating gate at J = A E^2 exp(-B/E), E = V_FG / t_ox,
* with representative SiO2 constants A = 1.25e-6 A/V^2 and B = 2.33e10 V/m. Program pulses of 10 us start at
* 15 V and rise 0.25 V per pulse; between pulses the gate returns to 0 V (the verify window).
* The threshold shift at the control gate is -Q_FG/C_CG = -(C_CG + C_TOX)/C_CG * V_FG while V_CG = 0.
.param cg=16e-18 ctox=12.332618739e-18 afn=1.25e-6 bfn=2.33e10 tox=7e-9 area=2.5e-15
.options reltol=1e-6 abstol=1e-22 vntol=1e-9 chgtol=1e-24 method=gear
VCG cg 0 PWL(0 0 1e-07 15.0000 1e-05 15.0000 1.01e-05 0 1.5e-05 0 1.51e-05 15.2500 2.5e-05 15.2500 2.51e-05 0 3e-05 0 3.01e-05 15.5000 4e-05 15.5000 4.01e-05 0 4.5e-05 0 4.51e-05 15.7500 5.5e-05 15.7500 5.51e-05 0 6e-05 0 6.01e-05 16.0000 7e-05 16.0000 7.01e-05 0 7.5e-05 0 7.51e-05 16.2500 8.5e-05 16.2500 8.51e-05 0 9e-05 0 9.01e-05 16.5000 0.0001 16.5000 0.0001001 0 0.000105 0 0.0001051 16.7500 0.000115 16.7500 0.0001151 0 0.00012 0 0.0001201 17.0000 0.00013 17.0000 0.0001301 0 0.000135 0 0.0001351 17.2500 0.000145 17.2500 0.0001451 0 0.00015 0 0.0001501 17.5000 0.00016 17.5000 0.0001601 0 0.000165 0 0.0001651 17.7500 0.000175 17.7500 0.0001751 0 0.00018 0 0.0001801 18.0000 0.00019 18.0000 0.0001901 0 0.000195 0 0.0001951 18.2500 0.000205 18.2500 0.0002051 0 0.00021 0 0.0002101 18.5000 0.00022 18.5000 0.0002201 0 0.000225 0 0.0002251 18.7500 0.000235 18.7500 0.0002351 0 0.00024 0 0.0002401 19.0000 0.00025 19.0000 0.0002501 0 0.000255 0 0.0002551 19.2500 0.000265 19.2500 0.0002651 0 0.00027 0 0.0002701 19.5000 0.00028 19.5000 0.0002801 0 0.000285 0 0.0002851 19.7500 0.000295 19.7500 0.0002951 0 0.0003 0 0.0003001 20.0000 0.00031 20.0000 0.0003101 0 0.000315 0 0.0003151 20.2500 0.000325 20.2500 0.0003251 0 0.00033 0 0.0003301 20.5000 0.00034 20.5000 0.0003401 0 0.000345 0 0.0003451 20.7500 0.000355 20.7500 0.0003551 0 0.00036 0 0.0003601 21.0000 0.00037 21.0000 0.0003701 0 0.000375 0 0.0003751 21.2500 0.000385 21.2500 0.0003851 0 0.00039 0 0.0003901 21.5000 0.0004 21.5000 0.0004001 0 0.000405 0 0.0004051 21.7500 0.000415 21.7500 0.0004151 0 0.00042 0 0.0004201 22.0000 0.00043 22.0000 0.0004301 0 0.000435 0 0.0004351 22.2500 0.000445 22.2500 0.0004451 0)
CCG cg fg {cg}
CTOX fg 0 {ctox}
* electron tunnelling into the gate: conventional current flows out of fg into the channel
BFN fg 0 I = afn*area*pow(max(v(fg),1e-3)/tox,2)*exp(-bfn/(max(v(fg),1e-3)/tox))
.tran 20n 451u uic
.control
run
let dvt = -(16e-18+12.332618739e-18)/16e-18*v(fg)
meas tran vt1 find dvt at=12.5u
meas tran vt28 find dvt at=417.5u
meas tran vt29 find dvt at=432.5u
meas tran vt30 find dvt at=447.5u
let step29 = vt29 - vt28
let step30 = vt30 - vt29
print step29 step30
.endc
* EXPECT vt1 key:README.md#Lab_23-06.a rtol=0.005
* EXPECT step30 key:README.md#Lab_23-06.b rtol=0.005
* EXPECT vt30 key:README.md#Lab_23-06.c rtol=0.005
.end
