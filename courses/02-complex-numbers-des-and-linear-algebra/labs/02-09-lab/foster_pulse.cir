* Lab 02-09 -- a datasheet-style Foster thermal network (Problem 02-09.14) hit by one 50 W, 10 ms pulse.
* Foster form: series chain of parallel (R_i, C_i) pairs with C_i = tau_i / R_i.
*   R1 = 0.2 K/W, tau1 = 1 ms  -> C1 = 5 mF
*   R2 = 0.5 K/W, tau2 = 50 ms -> C2 = 0.1 F
*   R3 = 1.3 K/W, tau3 = 2 s   -> C3 = 1.5385 F
* The voltage across the whole chain is the junction temperature rise (K) for the power (A) forced into it.
*
* EXPECT tj10 key:../../solutions/02-09-solutions.md#02-09.14c rtol=1e-3

Ip  0  j0 PULSE(0 50 0 1n 1n 10m 1)
R1  j0 j1 0.2
C1  j0 j1 5m   IC=0
R2  j1 j2 0.5
C2  j1 j2 0.1  IC=0
R3  j2 0  1.3
C3  j2 0  1.5384615 IC=0

.tran 1u 12m 0 1u UIC
.meas tran tj10 FIND v(j0) AT=10m
.end
