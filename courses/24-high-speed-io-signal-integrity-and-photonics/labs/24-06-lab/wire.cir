* 24-06 lab: energy and speed of a 2 mm unterminated interposer wire (Example 24-06.1)
* 40-section RC ladder, Rw = 50 ohm, Cw = 200 fF, 50 fF pads at each end, 50 ohm driver, 0.5 V step.
* Generated by make_wire.py.
* EXPECT esrc key:../../chapters/24-06-d2d-memory-phys-scale-up.md#Ex_24-06.1a scale=1e-15 rtol=0.002
* EXPECT trise key:../../chapters/24-06-d2d-memory-phys-scale-up.md#Txt_24-06.a scale=1e-12 rtol=0.005
* EXPECT tdel key:../../chapters/24-06-d2d-memory-phys-scale-up.md#Txt_24-06.b scale=1e-12 rtol=0.01
V1 in 0 PWL(0 0 10p 0 10.1p 0.5)
Ron in n0 50
R0 n0 n1 1.25
R1 n1 n2 1.25
R2 n2 n3 1.25
R3 n3 n4 1.25
R4 n4 n5 1.25
R5 n5 n6 1.25
R6 n6 n7 1.25
R7 n7 n8 1.25
R8 n8 n9 1.25
R9 n9 n10 1.25
R10 n10 n11 1.25
R11 n11 n12 1.25
R12 n12 n13 1.25
R13 n13 n14 1.25
R14 n14 n15 1.25
R15 n15 n16 1.25
R16 n16 n17 1.25
R17 n17 n18 1.25
R18 n18 n19 1.25
R19 n19 n20 1.25
R20 n20 n21 1.25
R21 n21 n22 1.25
R22 n22 n23 1.25
R23 n23 n24 1.25
R24 n24 n25 1.25
R25 n25 n26 1.25
R26 n26 n27 1.25
R27 n27 n28 1.25
R28 n28 n29 1.25
R29 n29 n30 1.25
R30 n30 n31 1.25
R31 n31 n32 1.25
R32 n32 n33 1.25
R33 n33 n34 1.25
R34 n34 n35 1.25
R35 n35 n36 1.25
R36 n36 n37 1.25
R37 n37 n38 1.25
R38 n38 n39 1.25
R39 n39 n40 1.25
C0 n0 0 5.25e-14
C1 n1 0 5e-15
C2 n2 0 5e-15
C3 n3 0 5e-15
C4 n4 0 5e-15
C5 n5 0 5e-15
C6 n6 0 5e-15
C7 n7 0 5e-15
C8 n8 0 5e-15
C9 n9 0 5e-15
C10 n10 0 5e-15
C11 n11 0 5e-15
C12 n12 0 5e-15
C13 n13 0 5e-15
C14 n14 0 5e-15
C15 n15 0 5e-15
C16 n16 0 5e-15
C17 n17 0 5e-15
C18 n18 0 5e-15
C19 n19 0 5e-15
C20 n20 0 5e-15
C21 n21 0 5e-15
C22 n22 0 5e-15
C23 n23 0 5e-15
C24 n24 0 5e-15
C25 n25 0 5e-15
C26 n26 0 5e-15
C27 n27 0 5e-15
C28 n28 0 5e-15
C29 n29 0 5e-15
C30 n30 0 5e-15
C31 n31 0 5e-15
C32 n32 0 5e-15
C33 n33 0 5e-15
C34 n34 0 5e-15
C35 n35 0 5e-15
C36 n36 0 5e-15
C37 n37 0 5e-15
C38 n38 0 5e-15
C39 n39 0 5e-15
C40 n40 0 5.25e-14
.control
tran 0.02p 1n 0 0.02p
let p = -v(in)*i(v1)
meas tran esrc integ p from=0 to=1n
meas tran t10 when v(n40)=0.05 rise=1
meas tran t90 when v(n40)=0.45 rise=1
let trise = t90 - t10
print trise
meas tran tdel trig v(in) val=0.25 rise=1 targ v(n40) val=0.25 rise=1
.endc
.end
