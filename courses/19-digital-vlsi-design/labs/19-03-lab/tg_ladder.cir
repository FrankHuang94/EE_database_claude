* Lab 19-03: twelve transmission gates modelled as an RC ladder (Example 19-03.5): 5 kOhm and 2 fF per section,
* driven by a step at t = 0; the 50% delay at the far end against the Elmore estimate ln 2 x 780 ps = 540.7 ps.
* EXPECT t50 key:../../chapters/19-03-logic-families.md#Ex_19-03.5b scale=1e-12 rtol=1e-3

VIN n0 0 PULSE(0 1 0 0.01p 0.01p 1u 2u)
R1 n0 n1 5k
C1 n1 0 2f
R2 n1 n2 5k
C2 n2 0 2f
R3 n2 n3 5k
C3 n3 0 2f
R4 n3 n4 5k
C4 n4 0 2f
R5 n4 n5 5k
C5 n5 0 2f
R6 n5 n6 5k
C6 n6 0 2f
R7 n6 n7 5k
C7 n7 0 2f
R8 n7 n8 5k
C8 n8 0 2f
R9 n8 n9 5k
C9 n9 0 2f
R10 n9 n10 5k
C10 n10 0 2f
R11 n10 n11 5k
C11 n11 0 2f
R12 n11 n12 5k
C12 n12 0 2f
.options reltol=1e-7 abstol=1e-15 vntol=1e-9
.tran 0.1p 3n 0 0.1p
.meas tran t50 WHEN v(n12)=0.5 RISE=1
.end
