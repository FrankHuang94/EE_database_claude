* Lab 20-06 -- the reference ladder of Example 20-06.2's 3-bit flash ADC: 0.8 V across resistors of 51, 98, 103,
* 100, 97, 104, 100 and 150 ohm from bottom to top (nominal 50, 6 x 100 and 150 ohm). The seven taps are the
* comparators' reference levels before their offsets. The control block also computes the endpoint DNL of codes
* 1 to 6 from the taps alone, showing how small the resistor errors' contribution is next to the comparator offsets.
*
* EXPECT t1 key:../../chapters/20-06-data-converter-fundamentals.md#Ex_20-06.2a scale=1e-3 rtol=1e-4
* EXPECT t2 key:../../chapters/20-06-data-converter-fundamentals.md#Ex_20-06.2b scale=1e-3 rtol=1e-4
* EXPECT t3 key:../../chapters/20-06-data-converter-fundamentals.md#Ex_20-06.2c scale=1e-3 rtol=1e-4
* EXPECT t4 key:../../chapters/20-06-data-converter-fundamentals.md#Ex_20-06.2d scale=1e-3 rtol=1e-4
* EXPECT t5 key:../../chapters/20-06-data-converter-fundamentals.md#Ex_20-06.2e scale=1e-3 rtol=1e-4
* EXPECT t6 key:../../chapters/20-06-data-converter-fundamentals.md#Ex_20-06.2f scale=1e-3 rtol=1e-4
* EXPECT t7 key:../../chapters/20-06-data-converter-fundamentals.md#Ex_20-06.2g scale=1e-3 rtol=1e-4
* EXPECT dnlmax key:README.md#Lab_20-06.u rtol=2e-2

VREF top 0 DC 0.8
R1 n1 0 51
R2 n2 n1 98
R3 n3 n2 103
R4 n4 n3 100
R5 n5 n4 97
R6 n6 n5 104
R7 n7 n6 100
R8 top n7 150

.control
op
let t1 = v(n1)
let t2 = v(n2)
let t3 = v(n3)
let t4 = v(n4)
let t5 = v(n5)
let t6 = v(n6)
let t7 = v(n7)
let davg = (t7 - t1)/6
let d1 = abs((t2 - t1)/davg - 1)
let d2 = abs((t3 - t2)/davg - 1)
let d3 = abs((t4 - t3)/davg - 1)
let d4 = abs((t5 - t4)/davg - 1)
let d5 = abs((t6 - t5)/davg - 1)
let d6 = abs((t7 - t6)/davg - 1)
let dnlmax = max(max(max(d1, d2), max(d3, d4)), max(d5, d6))
print t1 t2 t3 t4 t5 t6 t7 dnlmax
.endc
.end
