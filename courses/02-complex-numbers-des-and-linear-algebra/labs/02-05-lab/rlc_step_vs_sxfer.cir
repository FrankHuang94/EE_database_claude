* Chapter 02-05, Example 02-05.3 -- the series RLC step response two ways.
* Circuit 1: the physical circuit, L = 10 mH, C = 1 uF, R = 50 Ohm, 1 V step, at rest.
* Circuit 2: an XSPICE s_xfer block implementing H(s) = 1e8 / (s^2 + 5000 s + 1e8)
*            directly from the transfer function (no R, L or C at all).
* Both should overshoot to 1.4443 V (44.43 %) at t_p = pi/omega_d = 0.3245 ms.
* The s_xfer code model ships with ngspice's XSPICE extension (analog.cm).
*
* EXPECT os_ckt key:../../chapters/02-05-laplace-transform-for-odes.md#Ex_02-05.3b scale=1e-2 rtol=2e-3
* EXPECT os_sx  key:../../chapters/02-05-laplace-transform-for-odes.md#Ex_02-05.3b scale=1e-2 rtol=2e-3
* EXPECT tp_ckt key:../../chapters/02-05-laplace-transform-for-odes.md#Ex_02-05.3c scale=1e-3 rtol=2e-3

V1  in   0    PULSE(0 1 0 1n 1n 1 2)
R1  in   a    50
L1  a    c    10m
C1  c    0    1u

A1  in   out  hfilt
.model hfilt s_xfer(in_offset=0 gain=1 num_coeff=[1e8] den_coeff=[1 5000 1e8]
+ int_ic=[0 0] denormalized_freq=1)
RL  out  0    1k

* overshoot fractions (peak minus final value of 1 V)
BO1 o1   0    V = v(c) - 1
BO2 o2   0    V = v(out) - 1

.options reltol=1e-6
.tran 0.2u 2m 0 0.2u

.meas tran os_ckt MAX v(o1)
.meas tran os_sx  MAX v(o2)
.meas tran tp_ckt MAX_AT v(c)
.end
