* Lab 22-11, Part 1 -- Example 22-11.4: the per-phase equivalent circuit of a 400 V, 50 Hz, 4-pole induction motor
* (R1 = 0.5, X1 = 1.0, Xm = 30, R2 = 0.4, X2 = 1.0 ohm) solved by AC analysis at 50 Hz, at standstill (s = 1)
* and at 3% slip. Torque = 3 |I2|^2 (R2/s) / omega_s with omega_s = 50 pi rad/s.
* EXPECT tst key:../../chapters/22-11-electric-machines.md#Ex_22-11.4d rtol=1e-3
* EXPECT ist key:../../chapters/22-11-electric-machines.md#Ex_22-11.4h rtol=1e-3
* EXPECT trun key:../../chapters/22-11-electric-machines.md#Ex_22-11.4g rtol=1e-3
* EXPECT irun key:../../chapters/22-11-electric-machines.md#Ex_22-11.4i rtol=2e-3
V1 in 0 ac 230.940108
R1 in a 0.5
L1 a b 3.18309886m
Lm b 0 95.4929659m
L2 b c 3.18309886m
Vm c d 0
Rr d 0 0.4
.control
ac lin 1 50 50
let tst = 3*mag(i(vm))^2*0.4/(50*pi)
let ist = mag(i(v1))
print tst ist
alter Rr = 13.3333333
ac lin 1 50 50
let trun = 3*mag(i(vm))^2*13.3333333/(50*pi)
let irun = mag(i(v1))
print trun irun
.endc
.end
