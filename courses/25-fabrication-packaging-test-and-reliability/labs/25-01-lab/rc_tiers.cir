* 25-01 lab: 1 mm routes on three metal tiers as 200-section RC ladders (Example 25-01.6)
* Each ladder has the tier's total wire resistance and 200 fF total capacitance, open at the far end,
* driven by an ideal 1 V step. The 50% delay approaches 0.379 RC, the distributed-line value (19-05),
* from above: with 200 sections it is about 0.5% high, hence rtol = 0.01.
*   local        R = 74.0 kohm  -> 5.61 ns
*   intermediate R = 9.97 kohm  -> 0.755 ns
*   global       R = 60.1 ohm   -> 4.55 ps (below the 5.78 ps time of flight: RC alone no longer describes it)
*
* EXPECT dl key:../../chapters/25-01-process-flow-overview.md#Ex_25-01.6b scale=1e-9 rtol=0.01
* EXPECT di key:../../chapters/25-01-process-flow-overview.md#Ex_25-01.6b1 scale=1e-9 rtol=0.01
* EXPECT dg key:../../chapters/25-01-process-flow-overview.md#Ex_25-01.6b2 scale=1e-12 rtol=0.01

Vin in 0 PWL(0 0 1f 1)
* local tier
Rl1 in l1 370.066
Cl1 l1 0 1e-15
Rl2 l1 l2 370.066
Cl2 l2 0 1e-15
Rl3 l2 l3 370.066
Cl3 l3 0 1e-15
Rl4 l3 l4 370.066
Cl4 l4 0 1e-15
Rl5 l4 l5 370.066
Cl5 l5 0 1e-15
Rl6 l5 l6 370.066
Cl6 l6 0 1e-15
Rl7 l6 l7 370.066
Cl7 l7 0 1e-15
Rl8 l7 l8 370.066
Cl8 l8 0 1e-15
Rl9 l8 l9 370.066
Cl9 l9 0 1e-15
Rl10 l9 l10 370.066
Cl10 l10 0 1e-15
Rl11 l10 l11 370.066
Cl11 l11 0 1e-15
Rl12 l11 l12 370.066
Cl12 l12 0 1e-15
Rl13 l12 l13 370.066
Cl13 l13 0 1e-15
Rl14 l13 l14 370.066
Cl14 l14 0 1e-15
Rl15 l14 l15 370.066
Cl15 l15 0 1e-15
Rl16 l15 l16 370.066
Cl16 l16 0 1e-15
Rl17 l16 l17 370.066
Cl17 l17 0 1e-15
Rl18 l17 l18 370.066
Cl18 l18 0 1e-15
Rl19 l18 l19 370.066
Cl19 l19 0 1e-15
Rl20 l19 l20 370.066
Cl20 l20 0 1e-15
Rl21 l20 l21 370.066
Cl21 l21 0 1e-15
Rl22 l21 l22 370.066
Cl22 l22 0 1e-15
Rl23 l22 l23 370.066
Cl23 l23 0 1e-15
Rl24 l23 l24 370.066
Cl24 l24 0 1e-15
Rl25 l24 l25 370.066
Cl25 l25 0 1e-15
Rl26 l25 l26 370.066
Cl26 l26 0 1e-15
Rl27 l26 l27 370.066
Cl27 l27 0 1e-15
Rl28 l27 l28 370.066
Cl28 l28 0 1e-15
Rl29 l28 l29 370.066
Cl29 l29 0 1e-15
Rl30 l29 l30 370.066
Cl30 l30 0 1e-15
Rl31 l30 l31 370.066
Cl31 l31 0 1e-15
Rl32 l31 l32 370.066
Cl32 l32 0 1e-15
Rl33 l32 l33 370.066
Cl33 l33 0 1e-15
Rl34 l33 l34 370.066
Cl34 l34 0 1e-15
Rl35 l34 l35 370.066
Cl35 l35 0 1e-15
Rl36 l35 l36 370.066
Cl36 l36 0 1e-15
Rl37 l36 l37 370.066
Cl37 l37 0 1e-15
Rl38 l37 l38 370.066
Cl38 l38 0 1e-15
Rl39 l38 l39 370.066
Cl39 l39 0 1e-15
Rl40 l39 l40 370.066
Cl40 l40 0 1e-15
Rl41 l40 l41 370.066
Cl41 l41 0 1e-15
Rl42 l41 l42 370.066
Cl42 l42 0 1e-15
Rl43 l42 l43 370.066
Cl43 l43 0 1e-15
Rl44 l43 l44 370.066
Cl44 l44 0 1e-15
Rl45 l44 l45 370.066
Cl45 l45 0 1e-15
Rl46 l45 l46 370.066
Cl46 l46 0 1e-15
Rl47 l46 l47 370.066
Cl47 l47 0 1e-15
Rl48 l47 l48 370.066
Cl48 l48 0 1e-15
Rl49 l48 l49 370.066
Cl49 l49 0 1e-15
Rl50 l49 l50 370.066
Cl50 l50 0 1e-15
Rl51 l50 l51 370.066
Cl51 l51 0 1e-15
Rl52 l51 l52 370.066
Cl52 l52 0 1e-15
Rl53 l52 l53 370.066
Cl53 l53 0 1e-15
Rl54 l53 l54 370.066
Cl54 l54 0 1e-15
Rl55 l54 l55 370.066
Cl55 l55 0 1e-15
Rl56 l55 l56 370.066
Cl56 l56 0 1e-15
Rl57 l56 l57 370.066
Cl57 l57 0 1e-15
Rl58 l57 l58 370.066
Cl58 l58 0 1e-15
Rl59 l58 l59 370.066
Cl59 l59 0 1e-15
Rl60 l59 l60 370.066
Cl60 l60 0 1e-15
Rl61 l60 l61 370.066
Cl61 l61 0 1e-15
Rl62 l61 l62 370.066
Cl62 l62 0 1e-15
Rl63 l62 l63 370.066
Cl63 l63 0 1e-15
Rl64 l63 l64 370.066
Cl64 l64 0 1e-15
Rl65 l64 l65 370.066
Cl65 l65 0 1e-15
Rl66 l65 l66 370.066
Cl66 l66 0 1e-15
Rl67 l66 l67 370.066
Cl67 l67 0 1e-15
Rl68 l67 l68 370.066
Cl68 l68 0 1e-15
Rl69 l68 l69 370.066
Cl69 l69 0 1e-15
Rl70 l69 l70 370.066
Cl70 l70 0 1e-15
Rl71 l70 l71 370.066
Cl71 l71 0 1e-15
Rl72 l71 l72 370.066
Cl72 l72 0 1e-15
Rl73 l72 l73 370.066
Cl73 l73 0 1e-15
Rl74 l73 l74 370.066
Cl74 l74 0 1e-15
Rl75 l74 l75 370.066
Cl75 l75 0 1e-15
Rl76 l75 l76 370.066
Cl76 l76 0 1e-15
Rl77 l76 l77 370.066
Cl77 l77 0 1e-15
Rl78 l77 l78 370.066
Cl78 l78 0 1e-15
Rl79 l78 l79 370.066
Cl79 l79 0 1e-15
Rl80 l79 l80 370.066
Cl80 l80 0 1e-15
Rl81 l80 l81 370.066
Cl81 l81 0 1e-15
Rl82 l81 l82 370.066
Cl82 l82 0 1e-15
Rl83 l82 l83 370.066
Cl83 l83 0 1e-15
Rl84 l83 l84 370.066
Cl84 l84 0 1e-15
Rl85 l84 l85 370.066
Cl85 l85 0 1e-15
Rl86 l85 l86 370.066
Cl86 l86 0 1e-15
Rl87 l86 l87 370.066
Cl87 l87 0 1e-15
Rl88 l87 l88 370.066
Cl88 l88 0 1e-15
Rl89 l88 l89 370.066
Cl89 l89 0 1e-15
Rl90 l89 l90 370.066
Cl90 l90 0 1e-15
Rl91 l90 l91 370.066
Cl91 l91 0 1e-15
Rl92 l91 l92 370.066
Cl92 l92 0 1e-15
Rl93 l92 l93 370.066
Cl93 l93 0 1e-15
Rl94 l93 l94 370.066
Cl94 l94 0 1e-15
Rl95 l94 l95 370.066
Cl95 l95 0 1e-15
Rl96 l95 l96 370.066
Cl96 l96 0 1e-15
Rl97 l96 l97 370.066
Cl97 l97 0 1e-15
Rl98 l97 l98 370.066
Cl98 l98 0 1e-15
Rl99 l98 l99 370.066
Cl99 l99 0 1e-15
Rl100 l99 l100 370.066
Cl100 l100 0 1e-15
Rl101 l100 l101 370.066
Cl101 l101 0 1e-15
Rl102 l101 l102 370.066
Cl102 l102 0 1e-15
Rl103 l102 l103 370.066
Cl103 l103 0 1e-15
Rl104 l103 l104 370.066
Cl104 l104 0 1e-15
Rl105 l104 l105 370.066
Cl105 l105 0 1e-15
Rl106 l105 l106 370.066
Cl106 l106 0 1e-15
Rl107 l106 l107 370.066
Cl107 l107 0 1e-15
Rl108 l107 l108 370.066
Cl108 l108 0 1e-15
Rl109 l108 l109 370.066
Cl109 l109 0 1e-15
Rl110 l109 l110 370.066
Cl110 l110 0 1e-15
Rl111 l110 l111 370.066
Cl111 l111 0 1e-15
Rl112 l111 l112 370.066
Cl112 l112 0 1e-15
Rl113 l112 l113 370.066
Cl113 l113 0 1e-15
Rl114 l113 l114 370.066
Cl114 l114 0 1e-15
Rl115 l114 l115 370.066
Cl115 l115 0 1e-15
Rl116 l115 l116 370.066
Cl116 l116 0 1e-15
Rl117 l116 l117 370.066
Cl117 l117 0 1e-15
Rl118 l117 l118 370.066
Cl118 l118 0 1e-15
Rl119 l118 l119 370.066
Cl119 l119 0 1e-15
Rl120 l119 l120 370.066
Cl120 l120 0 1e-15
Rl121 l120 l121 370.066
Cl121 l121 0 1e-15
Rl122 l121 l122 370.066
Cl122 l122 0 1e-15
Rl123 l122 l123 370.066
Cl123 l123 0 1e-15
Rl124 l123 l124 370.066
Cl124 l124 0 1e-15
Rl125 l124 l125 370.066
Cl125 l125 0 1e-15
Rl126 l125 l126 370.066
Cl126 l126 0 1e-15
Rl127 l126 l127 370.066
Cl127 l127 0 1e-15
Rl128 l127 l128 370.066
Cl128 l128 0 1e-15
Rl129 l128 l129 370.066
Cl129 l129 0 1e-15
Rl130 l129 l130 370.066
Cl130 l130 0 1e-15
Rl131 l130 l131 370.066
Cl131 l131 0 1e-15
Rl132 l131 l132 370.066
Cl132 l132 0 1e-15
Rl133 l132 l133 370.066
Cl133 l133 0 1e-15
Rl134 l133 l134 370.066
Cl134 l134 0 1e-15
Rl135 l134 l135 370.066
Cl135 l135 0 1e-15
Rl136 l135 l136 370.066
Cl136 l136 0 1e-15
Rl137 l136 l137 370.066
Cl137 l137 0 1e-15
Rl138 l137 l138 370.066
Cl138 l138 0 1e-15
Rl139 l138 l139 370.066
Cl139 l139 0 1e-15
Rl140 l139 l140 370.066
Cl140 l140 0 1e-15
Rl141 l140 l141 370.066
Cl141 l141 0 1e-15
Rl142 l141 l142 370.066
Cl142 l142 0 1e-15
Rl143 l142 l143 370.066
Cl143 l143 0 1e-15
Rl144 l143 l144 370.066
Cl144 l144 0 1e-15
Rl145 l144 l145 370.066
Cl145 l145 0 1e-15
Rl146 l145 l146 370.066
Cl146 l146 0 1e-15
Rl147 l146 l147 370.066
Cl147 l147 0 1e-15
Rl148 l147 l148 370.066
Cl148 l148 0 1e-15
Rl149 l148 l149 370.066
Cl149 l149 0 1e-15
Rl150 l149 l150 370.066
Cl150 l150 0 1e-15
Rl151 l150 l151 370.066
Cl151 l151 0 1e-15
Rl152 l151 l152 370.066
Cl152 l152 0 1e-15
Rl153 l152 l153 370.066
Cl153 l153 0 1e-15
Rl154 l153 l154 370.066
Cl154 l154 0 1e-15
Rl155 l154 l155 370.066
Cl155 l155 0 1e-15
Rl156 l155 l156 370.066
Cl156 l156 0 1e-15
Rl157 l156 l157 370.066
Cl157 l157 0 1e-15
Rl158 l157 l158 370.066
Cl158 l158 0 1e-15
Rl159 l158 l159 370.066
Cl159 l159 0 1e-15
Rl160 l159 l160 370.066
Cl160 l160 0 1e-15
Rl161 l160 l161 370.066
Cl161 l161 0 1e-15
Rl162 l161 l162 370.066
Cl162 l162 0 1e-15
Rl163 l162 l163 370.066
Cl163 l163 0 1e-15
Rl164 l163 l164 370.066
Cl164 l164 0 1e-15
Rl165 l164 l165 370.066
Cl165 l165 0 1e-15
Rl166 l165 l166 370.066
Cl166 l166 0 1e-15
Rl167 l166 l167 370.066
Cl167 l167 0 1e-15
Rl168 l167 l168 370.066
Cl168 l168 0 1e-15
Rl169 l168 l169 370.066
Cl169 l169 0 1e-15
Rl170 l169 l170 370.066
Cl170 l170 0 1e-15
Rl171 l170 l171 370.066
Cl171 l171 0 1e-15
Rl172 l171 l172 370.066
Cl172 l172 0 1e-15
Rl173 l172 l173 370.066
Cl173 l173 0 1e-15
Rl174 l173 l174 370.066
Cl174 l174 0 1e-15
Rl175 l174 l175 370.066
Cl175 l175 0 1e-15
Rl176 l175 l176 370.066
Cl176 l176 0 1e-15
Rl177 l176 l177 370.066
Cl177 l177 0 1e-15
Rl178 l177 l178 370.066
Cl178 l178 0 1e-15
Rl179 l178 l179 370.066
Cl179 l179 0 1e-15
Rl180 l179 l180 370.066
Cl180 l180 0 1e-15
Rl181 l180 l181 370.066
Cl181 l181 0 1e-15
Rl182 l181 l182 370.066
Cl182 l182 0 1e-15
Rl183 l182 l183 370.066
Cl183 l183 0 1e-15
Rl184 l183 l184 370.066
Cl184 l184 0 1e-15
Rl185 l184 l185 370.066
Cl185 l185 0 1e-15
Rl186 l185 l186 370.066
Cl186 l186 0 1e-15
Rl187 l186 l187 370.066
Cl187 l187 0 1e-15
Rl188 l187 l188 370.066
Cl188 l188 0 1e-15
Rl189 l188 l189 370.066
Cl189 l189 0 1e-15
Rl190 l189 l190 370.066
Cl190 l190 0 1e-15
Rl191 l190 l191 370.066
Cl191 l191 0 1e-15
Rl192 l191 l192 370.066
Cl192 l192 0 1e-15
Rl193 l192 l193 370.066
Cl193 l193 0 1e-15
Rl194 l193 l194 370.066
Cl194 l194 0 1e-15
Rl195 l194 l195 370.066
Cl195 l195 0 1e-15
Rl196 l195 l196 370.066
Cl196 l196 0 1e-15
Rl197 l196 l197 370.066
Cl197 l197 0 1e-15
Rl198 l197 l198 370.066
Cl198 l198 0 1e-15
Rl199 l198 l199 370.066
Cl199 l199 0 1e-15
Rl200 l199 l200 370.066
Cl200 l200 0 1e-15
* intermediate tier
Ri1 in i1 49.8575
Ci1 i1 0 1e-15
Ri2 i1 i2 49.8575
Ci2 i2 0 1e-15
Ri3 i2 i3 49.8575
Ci3 i3 0 1e-15
Ri4 i3 i4 49.8575
Ci4 i4 0 1e-15
Ri5 i4 i5 49.8575
Ci5 i5 0 1e-15
Ri6 i5 i6 49.8575
Ci6 i6 0 1e-15
Ri7 i6 i7 49.8575
Ci7 i7 0 1e-15
Ri8 i7 i8 49.8575
Ci8 i8 0 1e-15
Ri9 i8 i9 49.8575
Ci9 i9 0 1e-15
Ri10 i9 i10 49.8575
Ci10 i10 0 1e-15
Ri11 i10 i11 49.8575
Ci11 i11 0 1e-15
Ri12 i11 i12 49.8575
Ci12 i12 0 1e-15
Ri13 i12 i13 49.8575
Ci13 i13 0 1e-15
Ri14 i13 i14 49.8575
Ci14 i14 0 1e-15
Ri15 i14 i15 49.8575
Ci15 i15 0 1e-15
Ri16 i15 i16 49.8575
Ci16 i16 0 1e-15
Ri17 i16 i17 49.8575
Ci17 i17 0 1e-15
Ri18 i17 i18 49.8575
Ci18 i18 0 1e-15
Ri19 i18 i19 49.8575
Ci19 i19 0 1e-15
Ri20 i19 i20 49.8575
Ci20 i20 0 1e-15
Ri21 i20 i21 49.8575
Ci21 i21 0 1e-15
Ri22 i21 i22 49.8575
Ci22 i22 0 1e-15
Ri23 i22 i23 49.8575
Ci23 i23 0 1e-15
Ri24 i23 i24 49.8575
Ci24 i24 0 1e-15
Ri25 i24 i25 49.8575
Ci25 i25 0 1e-15
Ri26 i25 i26 49.8575
Ci26 i26 0 1e-15
Ri27 i26 i27 49.8575
Ci27 i27 0 1e-15
Ri28 i27 i28 49.8575
Ci28 i28 0 1e-15
Ri29 i28 i29 49.8575
Ci29 i29 0 1e-15
Ri30 i29 i30 49.8575
Ci30 i30 0 1e-15
Ri31 i30 i31 49.8575
Ci31 i31 0 1e-15
Ri32 i31 i32 49.8575
Ci32 i32 0 1e-15
Ri33 i32 i33 49.8575
Ci33 i33 0 1e-15
Ri34 i33 i34 49.8575
Ci34 i34 0 1e-15
Ri35 i34 i35 49.8575
Ci35 i35 0 1e-15
Ri36 i35 i36 49.8575
Ci36 i36 0 1e-15
Ri37 i36 i37 49.8575
Ci37 i37 0 1e-15
Ri38 i37 i38 49.8575
Ci38 i38 0 1e-15
Ri39 i38 i39 49.8575
Ci39 i39 0 1e-15
Ri40 i39 i40 49.8575
Ci40 i40 0 1e-15
Ri41 i40 i41 49.8575
Ci41 i41 0 1e-15
Ri42 i41 i42 49.8575
Ci42 i42 0 1e-15
Ri43 i42 i43 49.8575
Ci43 i43 0 1e-15
Ri44 i43 i44 49.8575
Ci44 i44 0 1e-15
Ri45 i44 i45 49.8575
Ci45 i45 0 1e-15
Ri46 i45 i46 49.8575
Ci46 i46 0 1e-15
Ri47 i46 i47 49.8575
Ci47 i47 0 1e-15
Ri48 i47 i48 49.8575
Ci48 i48 0 1e-15
Ri49 i48 i49 49.8575
Ci49 i49 0 1e-15
Ri50 i49 i50 49.8575
Ci50 i50 0 1e-15
Ri51 i50 i51 49.8575
Ci51 i51 0 1e-15
Ri52 i51 i52 49.8575
Ci52 i52 0 1e-15
Ri53 i52 i53 49.8575
Ci53 i53 0 1e-15
Ri54 i53 i54 49.8575
Ci54 i54 0 1e-15
Ri55 i54 i55 49.8575
Ci55 i55 0 1e-15
Ri56 i55 i56 49.8575
Ci56 i56 0 1e-15
Ri57 i56 i57 49.8575
Ci57 i57 0 1e-15
Ri58 i57 i58 49.8575
Ci58 i58 0 1e-15
Ri59 i58 i59 49.8575
Ci59 i59 0 1e-15
Ri60 i59 i60 49.8575
Ci60 i60 0 1e-15
Ri61 i60 i61 49.8575
Ci61 i61 0 1e-15
Ri62 i61 i62 49.8575
Ci62 i62 0 1e-15
Ri63 i62 i63 49.8575
Ci63 i63 0 1e-15
Ri64 i63 i64 49.8575
Ci64 i64 0 1e-15
Ri65 i64 i65 49.8575
Ci65 i65 0 1e-15
Ri66 i65 i66 49.8575
Ci66 i66 0 1e-15
Ri67 i66 i67 49.8575
Ci67 i67 0 1e-15
Ri68 i67 i68 49.8575
Ci68 i68 0 1e-15
Ri69 i68 i69 49.8575
Ci69 i69 0 1e-15
Ri70 i69 i70 49.8575
Ci70 i70 0 1e-15
Ri71 i70 i71 49.8575
Ci71 i71 0 1e-15
Ri72 i71 i72 49.8575
Ci72 i72 0 1e-15
Ri73 i72 i73 49.8575
Ci73 i73 0 1e-15
Ri74 i73 i74 49.8575
Ci74 i74 0 1e-15
Ri75 i74 i75 49.8575
Ci75 i75 0 1e-15
Ri76 i75 i76 49.8575
Ci76 i76 0 1e-15
Ri77 i76 i77 49.8575
Ci77 i77 0 1e-15
Ri78 i77 i78 49.8575
Ci78 i78 0 1e-15
Ri79 i78 i79 49.8575
Ci79 i79 0 1e-15
Ri80 i79 i80 49.8575
Ci80 i80 0 1e-15
Ri81 i80 i81 49.8575
Ci81 i81 0 1e-15
Ri82 i81 i82 49.8575
Ci82 i82 0 1e-15
Ri83 i82 i83 49.8575
Ci83 i83 0 1e-15
Ri84 i83 i84 49.8575
Ci84 i84 0 1e-15
Ri85 i84 i85 49.8575
Ci85 i85 0 1e-15
Ri86 i85 i86 49.8575
Ci86 i86 0 1e-15
Ri87 i86 i87 49.8575
Ci87 i87 0 1e-15
Ri88 i87 i88 49.8575
Ci88 i88 0 1e-15
Ri89 i88 i89 49.8575
Ci89 i89 0 1e-15
Ri90 i89 i90 49.8575
Ci90 i90 0 1e-15
Ri91 i90 i91 49.8575
Ci91 i91 0 1e-15
Ri92 i91 i92 49.8575
Ci92 i92 0 1e-15
Ri93 i92 i93 49.8575
Ci93 i93 0 1e-15
Ri94 i93 i94 49.8575
Ci94 i94 0 1e-15
Ri95 i94 i95 49.8575
Ci95 i95 0 1e-15
Ri96 i95 i96 49.8575
Ci96 i96 0 1e-15
Ri97 i96 i97 49.8575
Ci97 i97 0 1e-15
Ri98 i97 i98 49.8575
Ci98 i98 0 1e-15
Ri99 i98 i99 49.8575
Ci99 i99 0 1e-15
Ri100 i99 i100 49.8575
Ci100 i100 0 1e-15
Ri101 i100 i101 49.8575
Ci101 i101 0 1e-15
Ri102 i101 i102 49.8575
Ci102 i102 0 1e-15
Ri103 i102 i103 49.8575
Ci103 i103 0 1e-15
Ri104 i103 i104 49.8575
Ci104 i104 0 1e-15
Ri105 i104 i105 49.8575
Ci105 i105 0 1e-15
Ri106 i105 i106 49.8575
Ci106 i106 0 1e-15
Ri107 i106 i107 49.8575
Ci107 i107 0 1e-15
Ri108 i107 i108 49.8575
Ci108 i108 0 1e-15
Ri109 i108 i109 49.8575
Ci109 i109 0 1e-15
Ri110 i109 i110 49.8575
Ci110 i110 0 1e-15
Ri111 i110 i111 49.8575
Ci111 i111 0 1e-15
Ri112 i111 i112 49.8575
Ci112 i112 0 1e-15
Ri113 i112 i113 49.8575
Ci113 i113 0 1e-15
Ri114 i113 i114 49.8575
Ci114 i114 0 1e-15
Ri115 i114 i115 49.8575
Ci115 i115 0 1e-15
Ri116 i115 i116 49.8575
Ci116 i116 0 1e-15
Ri117 i116 i117 49.8575
Ci117 i117 0 1e-15
Ri118 i117 i118 49.8575
Ci118 i118 0 1e-15
Ri119 i118 i119 49.8575
Ci119 i119 0 1e-15
Ri120 i119 i120 49.8575
Ci120 i120 0 1e-15
Ri121 i120 i121 49.8575
Ci121 i121 0 1e-15
Ri122 i121 i122 49.8575
Ci122 i122 0 1e-15
Ri123 i122 i123 49.8575
Ci123 i123 0 1e-15
Ri124 i123 i124 49.8575
Ci124 i124 0 1e-15
Ri125 i124 i125 49.8575
Ci125 i125 0 1e-15
Ri126 i125 i126 49.8575
Ci126 i126 0 1e-15
Ri127 i126 i127 49.8575
Ci127 i127 0 1e-15
Ri128 i127 i128 49.8575
Ci128 i128 0 1e-15
Ri129 i128 i129 49.8575
Ci129 i129 0 1e-15
Ri130 i129 i130 49.8575
Ci130 i130 0 1e-15
Ri131 i130 i131 49.8575
Ci131 i131 0 1e-15
Ri132 i131 i132 49.8575
Ci132 i132 0 1e-15
Ri133 i132 i133 49.8575
Ci133 i133 0 1e-15
Ri134 i133 i134 49.8575
Ci134 i134 0 1e-15
Ri135 i134 i135 49.8575
Ci135 i135 0 1e-15
Ri136 i135 i136 49.8575
Ci136 i136 0 1e-15
Ri137 i136 i137 49.8575
Ci137 i137 0 1e-15
Ri138 i137 i138 49.8575
Ci138 i138 0 1e-15
Ri139 i138 i139 49.8575
Ci139 i139 0 1e-15
Ri140 i139 i140 49.8575
Ci140 i140 0 1e-15
Ri141 i140 i141 49.8575
Ci141 i141 0 1e-15
Ri142 i141 i142 49.8575
Ci142 i142 0 1e-15
Ri143 i142 i143 49.8575
Ci143 i143 0 1e-15
Ri144 i143 i144 49.8575
Ci144 i144 0 1e-15
Ri145 i144 i145 49.8575
Ci145 i145 0 1e-15
Ri146 i145 i146 49.8575
Ci146 i146 0 1e-15
Ri147 i146 i147 49.8575
Ci147 i147 0 1e-15
Ri148 i147 i148 49.8575
Ci148 i148 0 1e-15
Ri149 i148 i149 49.8575
Ci149 i149 0 1e-15
Ri150 i149 i150 49.8575
Ci150 i150 0 1e-15
Ri151 i150 i151 49.8575
Ci151 i151 0 1e-15
Ri152 i151 i152 49.8575
Ci152 i152 0 1e-15
Ri153 i152 i153 49.8575
Ci153 i153 0 1e-15
Ri154 i153 i154 49.8575
Ci154 i154 0 1e-15
Ri155 i154 i155 49.8575
Ci155 i155 0 1e-15
Ri156 i155 i156 49.8575
Ci156 i156 0 1e-15
Ri157 i156 i157 49.8575
Ci157 i157 0 1e-15
Ri158 i157 i158 49.8575
Ci158 i158 0 1e-15
Ri159 i158 i159 49.8575
Ci159 i159 0 1e-15
Ri160 i159 i160 49.8575
Ci160 i160 0 1e-15
Ri161 i160 i161 49.8575
Ci161 i161 0 1e-15
Ri162 i161 i162 49.8575
Ci162 i162 0 1e-15
Ri163 i162 i163 49.8575
Ci163 i163 0 1e-15
Ri164 i163 i164 49.8575
Ci164 i164 0 1e-15
Ri165 i164 i165 49.8575
Ci165 i165 0 1e-15
Ri166 i165 i166 49.8575
Ci166 i166 0 1e-15
Ri167 i166 i167 49.8575
Ci167 i167 0 1e-15
Ri168 i167 i168 49.8575
Ci168 i168 0 1e-15
Ri169 i168 i169 49.8575
Ci169 i169 0 1e-15
Ri170 i169 i170 49.8575
Ci170 i170 0 1e-15
Ri171 i170 i171 49.8575
Ci171 i171 0 1e-15
Ri172 i171 i172 49.8575
Ci172 i172 0 1e-15
Ri173 i172 i173 49.8575
Ci173 i173 0 1e-15
Ri174 i173 i174 49.8575
Ci174 i174 0 1e-15
Ri175 i174 i175 49.8575
Ci175 i175 0 1e-15
Ri176 i175 i176 49.8575
Ci176 i176 0 1e-15
Ri177 i176 i177 49.8575
Ci177 i177 0 1e-15
Ri178 i177 i178 49.8575
Ci178 i178 0 1e-15
Ri179 i178 i179 49.8575
Ci179 i179 0 1e-15
Ri180 i179 i180 49.8575
Ci180 i180 0 1e-15
Ri181 i180 i181 49.8575
Ci181 i181 0 1e-15
Ri182 i181 i182 49.8575
Ci182 i182 0 1e-15
Ri183 i182 i183 49.8575
Ci183 i183 0 1e-15
Ri184 i183 i184 49.8575
Ci184 i184 0 1e-15
Ri185 i184 i185 49.8575
Ci185 i185 0 1e-15
Ri186 i185 i186 49.8575
Ci186 i186 0 1e-15
Ri187 i186 i187 49.8575
Ci187 i187 0 1e-15
Ri188 i187 i188 49.8575
Ci188 i188 0 1e-15
Ri189 i188 i189 49.8575
Ci189 i189 0 1e-15
Ri190 i189 i190 49.8575
Ci190 i190 0 1e-15
Ri191 i190 i191 49.8575
Ci191 i191 0 1e-15
Ri192 i191 i192 49.8575
Ci192 i192 0 1e-15
Ri193 i192 i193 49.8575
Ci193 i193 0 1e-15
Ri194 i193 i194 49.8575
Ci194 i194 0 1e-15
Ri195 i194 i195 49.8575
Ci195 i195 0 1e-15
Ri196 i195 i196 49.8575
Ci196 i196 0 1e-15
Ri197 i196 i197 49.8575
Ci197 i197 0 1e-15
Ri198 i197 i198 49.8575
Ci198 i198 0 1e-15
Ri199 i198 i199 49.8575
Ci199 i199 0 1e-15
Ri200 i199 i200 49.8575
Ci200 i200 0 1e-15
* global tier
Rg1 in g1 0.300625
Cg1 g1 0 1e-15
Rg2 g1 g2 0.300625
Cg2 g2 0 1e-15
Rg3 g2 g3 0.300625
Cg3 g3 0 1e-15
Rg4 g3 g4 0.300625
Cg4 g4 0 1e-15
Rg5 g4 g5 0.300625
Cg5 g5 0 1e-15
Rg6 g5 g6 0.300625
Cg6 g6 0 1e-15
Rg7 g6 g7 0.300625
Cg7 g7 0 1e-15
Rg8 g7 g8 0.300625
Cg8 g8 0 1e-15
Rg9 g8 g9 0.300625
Cg9 g9 0 1e-15
Rg10 g9 g10 0.300625
Cg10 g10 0 1e-15
Rg11 g10 g11 0.300625
Cg11 g11 0 1e-15
Rg12 g11 g12 0.300625
Cg12 g12 0 1e-15
Rg13 g12 g13 0.300625
Cg13 g13 0 1e-15
Rg14 g13 g14 0.300625
Cg14 g14 0 1e-15
Rg15 g14 g15 0.300625
Cg15 g15 0 1e-15
Rg16 g15 g16 0.300625
Cg16 g16 0 1e-15
Rg17 g16 g17 0.300625
Cg17 g17 0 1e-15
Rg18 g17 g18 0.300625
Cg18 g18 0 1e-15
Rg19 g18 g19 0.300625
Cg19 g19 0 1e-15
Rg20 g19 g20 0.300625
Cg20 g20 0 1e-15
Rg21 g20 g21 0.300625
Cg21 g21 0 1e-15
Rg22 g21 g22 0.300625
Cg22 g22 0 1e-15
Rg23 g22 g23 0.300625
Cg23 g23 0 1e-15
Rg24 g23 g24 0.300625
Cg24 g24 0 1e-15
Rg25 g24 g25 0.300625
Cg25 g25 0 1e-15
Rg26 g25 g26 0.300625
Cg26 g26 0 1e-15
Rg27 g26 g27 0.300625
Cg27 g27 0 1e-15
Rg28 g27 g28 0.300625
Cg28 g28 0 1e-15
Rg29 g28 g29 0.300625
Cg29 g29 0 1e-15
Rg30 g29 g30 0.300625
Cg30 g30 0 1e-15
Rg31 g30 g31 0.300625
Cg31 g31 0 1e-15
Rg32 g31 g32 0.300625
Cg32 g32 0 1e-15
Rg33 g32 g33 0.300625
Cg33 g33 0 1e-15
Rg34 g33 g34 0.300625
Cg34 g34 0 1e-15
Rg35 g34 g35 0.300625
Cg35 g35 0 1e-15
Rg36 g35 g36 0.300625
Cg36 g36 0 1e-15
Rg37 g36 g37 0.300625
Cg37 g37 0 1e-15
Rg38 g37 g38 0.300625
Cg38 g38 0 1e-15
Rg39 g38 g39 0.300625
Cg39 g39 0 1e-15
Rg40 g39 g40 0.300625
Cg40 g40 0 1e-15
Rg41 g40 g41 0.300625
Cg41 g41 0 1e-15
Rg42 g41 g42 0.300625
Cg42 g42 0 1e-15
Rg43 g42 g43 0.300625
Cg43 g43 0 1e-15
Rg44 g43 g44 0.300625
Cg44 g44 0 1e-15
Rg45 g44 g45 0.300625
Cg45 g45 0 1e-15
Rg46 g45 g46 0.300625
Cg46 g46 0 1e-15
Rg47 g46 g47 0.300625
Cg47 g47 0 1e-15
Rg48 g47 g48 0.300625
Cg48 g48 0 1e-15
Rg49 g48 g49 0.300625
Cg49 g49 0 1e-15
Rg50 g49 g50 0.300625
Cg50 g50 0 1e-15
Rg51 g50 g51 0.300625
Cg51 g51 0 1e-15
Rg52 g51 g52 0.300625
Cg52 g52 0 1e-15
Rg53 g52 g53 0.300625
Cg53 g53 0 1e-15
Rg54 g53 g54 0.300625
Cg54 g54 0 1e-15
Rg55 g54 g55 0.300625
Cg55 g55 0 1e-15
Rg56 g55 g56 0.300625
Cg56 g56 0 1e-15
Rg57 g56 g57 0.300625
Cg57 g57 0 1e-15
Rg58 g57 g58 0.300625
Cg58 g58 0 1e-15
Rg59 g58 g59 0.300625
Cg59 g59 0 1e-15
Rg60 g59 g60 0.300625
Cg60 g60 0 1e-15
Rg61 g60 g61 0.300625
Cg61 g61 0 1e-15
Rg62 g61 g62 0.300625
Cg62 g62 0 1e-15
Rg63 g62 g63 0.300625
Cg63 g63 0 1e-15
Rg64 g63 g64 0.300625
Cg64 g64 0 1e-15
Rg65 g64 g65 0.300625
Cg65 g65 0 1e-15
Rg66 g65 g66 0.300625
Cg66 g66 0 1e-15
Rg67 g66 g67 0.300625
Cg67 g67 0 1e-15
Rg68 g67 g68 0.300625
Cg68 g68 0 1e-15
Rg69 g68 g69 0.300625
Cg69 g69 0 1e-15
Rg70 g69 g70 0.300625
Cg70 g70 0 1e-15
Rg71 g70 g71 0.300625
Cg71 g71 0 1e-15
Rg72 g71 g72 0.300625
Cg72 g72 0 1e-15
Rg73 g72 g73 0.300625
Cg73 g73 0 1e-15
Rg74 g73 g74 0.300625
Cg74 g74 0 1e-15
Rg75 g74 g75 0.300625
Cg75 g75 0 1e-15
Rg76 g75 g76 0.300625
Cg76 g76 0 1e-15
Rg77 g76 g77 0.300625
Cg77 g77 0 1e-15
Rg78 g77 g78 0.300625
Cg78 g78 0 1e-15
Rg79 g78 g79 0.300625
Cg79 g79 0 1e-15
Rg80 g79 g80 0.300625
Cg80 g80 0 1e-15
Rg81 g80 g81 0.300625
Cg81 g81 0 1e-15
Rg82 g81 g82 0.300625
Cg82 g82 0 1e-15
Rg83 g82 g83 0.300625
Cg83 g83 0 1e-15
Rg84 g83 g84 0.300625
Cg84 g84 0 1e-15
Rg85 g84 g85 0.300625
Cg85 g85 0 1e-15
Rg86 g85 g86 0.300625
Cg86 g86 0 1e-15
Rg87 g86 g87 0.300625
Cg87 g87 0 1e-15
Rg88 g87 g88 0.300625
Cg88 g88 0 1e-15
Rg89 g88 g89 0.300625
Cg89 g89 0 1e-15
Rg90 g89 g90 0.300625
Cg90 g90 0 1e-15
Rg91 g90 g91 0.300625
Cg91 g91 0 1e-15
Rg92 g91 g92 0.300625
Cg92 g92 0 1e-15
Rg93 g92 g93 0.300625
Cg93 g93 0 1e-15
Rg94 g93 g94 0.300625
Cg94 g94 0 1e-15
Rg95 g94 g95 0.300625
Cg95 g95 0 1e-15
Rg96 g95 g96 0.300625
Cg96 g96 0 1e-15
Rg97 g96 g97 0.300625
Cg97 g97 0 1e-15
Rg98 g97 g98 0.300625
Cg98 g98 0 1e-15
Rg99 g98 g99 0.300625
Cg99 g99 0 1e-15
Rg100 g99 g100 0.300625
Cg100 g100 0 1e-15
Rg101 g100 g101 0.300625
Cg101 g101 0 1e-15
Rg102 g101 g102 0.300625
Cg102 g102 0 1e-15
Rg103 g102 g103 0.300625
Cg103 g103 0 1e-15
Rg104 g103 g104 0.300625
Cg104 g104 0 1e-15
Rg105 g104 g105 0.300625
Cg105 g105 0 1e-15
Rg106 g105 g106 0.300625
Cg106 g106 0 1e-15
Rg107 g106 g107 0.300625
Cg107 g107 0 1e-15
Rg108 g107 g108 0.300625
Cg108 g108 0 1e-15
Rg109 g108 g109 0.300625
Cg109 g109 0 1e-15
Rg110 g109 g110 0.300625
Cg110 g110 0 1e-15
Rg111 g110 g111 0.300625
Cg111 g111 0 1e-15
Rg112 g111 g112 0.300625
Cg112 g112 0 1e-15
Rg113 g112 g113 0.300625
Cg113 g113 0 1e-15
Rg114 g113 g114 0.300625
Cg114 g114 0 1e-15
Rg115 g114 g115 0.300625
Cg115 g115 0 1e-15
Rg116 g115 g116 0.300625
Cg116 g116 0 1e-15
Rg117 g116 g117 0.300625
Cg117 g117 0 1e-15
Rg118 g117 g118 0.300625
Cg118 g118 0 1e-15
Rg119 g118 g119 0.300625
Cg119 g119 0 1e-15
Rg120 g119 g120 0.300625
Cg120 g120 0 1e-15
Rg121 g120 g121 0.300625
Cg121 g121 0 1e-15
Rg122 g121 g122 0.300625
Cg122 g122 0 1e-15
Rg123 g122 g123 0.300625
Cg123 g123 0 1e-15
Rg124 g123 g124 0.300625
Cg124 g124 0 1e-15
Rg125 g124 g125 0.300625
Cg125 g125 0 1e-15
Rg126 g125 g126 0.300625
Cg126 g126 0 1e-15
Rg127 g126 g127 0.300625
Cg127 g127 0 1e-15
Rg128 g127 g128 0.300625
Cg128 g128 0 1e-15
Rg129 g128 g129 0.300625
Cg129 g129 0 1e-15
Rg130 g129 g130 0.300625
Cg130 g130 0 1e-15
Rg131 g130 g131 0.300625
Cg131 g131 0 1e-15
Rg132 g131 g132 0.300625
Cg132 g132 0 1e-15
Rg133 g132 g133 0.300625
Cg133 g133 0 1e-15
Rg134 g133 g134 0.300625
Cg134 g134 0 1e-15
Rg135 g134 g135 0.300625
Cg135 g135 0 1e-15
Rg136 g135 g136 0.300625
Cg136 g136 0 1e-15
Rg137 g136 g137 0.300625
Cg137 g137 0 1e-15
Rg138 g137 g138 0.300625
Cg138 g138 0 1e-15
Rg139 g138 g139 0.300625
Cg139 g139 0 1e-15
Rg140 g139 g140 0.300625
Cg140 g140 0 1e-15
Rg141 g140 g141 0.300625
Cg141 g141 0 1e-15
Rg142 g141 g142 0.300625
Cg142 g142 0 1e-15
Rg143 g142 g143 0.300625
Cg143 g143 0 1e-15
Rg144 g143 g144 0.300625
Cg144 g144 0 1e-15
Rg145 g144 g145 0.300625
Cg145 g145 0 1e-15
Rg146 g145 g146 0.300625
Cg146 g146 0 1e-15
Rg147 g146 g147 0.300625
Cg147 g147 0 1e-15
Rg148 g147 g148 0.300625
Cg148 g148 0 1e-15
Rg149 g148 g149 0.300625
Cg149 g149 0 1e-15
Rg150 g149 g150 0.300625
Cg150 g150 0 1e-15
Rg151 g150 g151 0.300625
Cg151 g151 0 1e-15
Rg152 g151 g152 0.300625
Cg152 g152 0 1e-15
Rg153 g152 g153 0.300625
Cg153 g153 0 1e-15
Rg154 g153 g154 0.300625
Cg154 g154 0 1e-15
Rg155 g154 g155 0.300625
Cg155 g155 0 1e-15
Rg156 g155 g156 0.300625
Cg156 g156 0 1e-15
Rg157 g156 g157 0.300625
Cg157 g157 0 1e-15
Rg158 g157 g158 0.300625
Cg158 g158 0 1e-15
Rg159 g158 g159 0.300625
Cg159 g159 0 1e-15
Rg160 g159 g160 0.300625
Cg160 g160 0 1e-15
Rg161 g160 g161 0.300625
Cg161 g161 0 1e-15
Rg162 g161 g162 0.300625
Cg162 g162 0 1e-15
Rg163 g162 g163 0.300625
Cg163 g163 0 1e-15
Rg164 g163 g164 0.300625
Cg164 g164 0 1e-15
Rg165 g164 g165 0.300625
Cg165 g165 0 1e-15
Rg166 g165 g166 0.300625
Cg166 g166 0 1e-15
Rg167 g166 g167 0.300625
Cg167 g167 0 1e-15
Rg168 g167 g168 0.300625
Cg168 g168 0 1e-15
Rg169 g168 g169 0.300625
Cg169 g169 0 1e-15
Rg170 g169 g170 0.300625
Cg170 g170 0 1e-15
Rg171 g170 g171 0.300625
Cg171 g171 0 1e-15
Rg172 g171 g172 0.300625
Cg172 g172 0 1e-15
Rg173 g172 g173 0.300625
Cg173 g173 0 1e-15
Rg174 g173 g174 0.300625
Cg174 g174 0 1e-15
Rg175 g174 g175 0.300625
Cg175 g175 0 1e-15
Rg176 g175 g176 0.300625
Cg176 g176 0 1e-15
Rg177 g176 g177 0.300625
Cg177 g177 0 1e-15
Rg178 g177 g178 0.300625
Cg178 g178 0 1e-15
Rg179 g178 g179 0.300625
Cg179 g179 0 1e-15
Rg180 g179 g180 0.300625
Cg180 g180 0 1e-15
Rg181 g180 g181 0.300625
Cg181 g181 0 1e-15
Rg182 g181 g182 0.300625
Cg182 g182 0 1e-15
Rg183 g182 g183 0.300625
Cg183 g183 0 1e-15
Rg184 g183 g184 0.300625
Cg184 g184 0 1e-15
Rg185 g184 g185 0.300625
Cg185 g185 0 1e-15
Rg186 g185 g186 0.300625
Cg186 g186 0 1e-15
Rg187 g186 g187 0.300625
Cg187 g187 0 1e-15
Rg188 g187 g188 0.300625
Cg188 g188 0 1e-15
Rg189 g188 g189 0.300625
Cg189 g189 0 1e-15
Rg190 g189 g190 0.300625
Cg190 g190 0 1e-15
Rg191 g190 g191 0.300625
Cg191 g191 0 1e-15
Rg192 g191 g192 0.300625
Cg192 g192 0 1e-15
Rg193 g192 g193 0.300625
Cg193 g193 0 1e-15
Rg194 g193 g194 0.300625
Cg194 g194 0 1e-15
Rg195 g194 g195 0.300625
Cg195 g195 0 1e-15
Rg196 g195 g196 0.300625
Cg196 g196 0 1e-15
Rg197 g196 g197 0.300625
Cg197 g197 0 1e-15
Rg198 g197 g198 0.300625
Cg198 g198 0 1e-15
Rg199 g198 g199 0.300625
Cg199 g199 0 1e-15
Rg200 g199 g200 0.300625
Cg200 g200 0 1e-15

.control
tran 2p 20n
meas tran dl trig v(in) val=0.5 rise=1 targ v(l200) val=0.5 rise=1
tran 0.2p 3n
meas tran di trig v(in) val=0.5 rise=1 targ v(i200) val=0.5 rise=1
tran 0.002p 20p
meas tran dg trig v(in) val=0.5 rise=1 targ v(g200) val=0.5 rise=1
.endc
.end
