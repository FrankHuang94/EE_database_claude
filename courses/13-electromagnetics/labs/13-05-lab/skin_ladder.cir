* Lab 13-05 -- the skin effect as a circuit: one square of a copper surface at 1 GHz.
* Inside a good conductor the field obeys dE/dz = -j omega mu H and dH/dz = -sigma E (displacement current
* neglected). Slicing the metal into layers of thickness h turns these into a ladder: each layer adds a series
* inductance mu0*h (the flux between layers) and a shunt resistor 1/(sigma*h) (the layer's sheet resistance).
* The surface node carries only half a layer (shunt 2/(sigma*h)), which makes each section symmetric and the
* discretization error second order. Driving the surface node with 1 A gives the surface impedance
* Zs = Rs(1 + j), Rs = 1/(sigma*delta).
* Here delta = 2.0898 um, h = delta/20, 240 layers (12 skin depths deep).
*
* EXPECT zr key:../../chapters/13-05-plane-waves.md#Sim_13-05.a scale=1e-3 rtol=2e-3
* EXPECT zi key:../../chapters/13-05-plane-waves.md#Sim_13-05.b scale=1e-3 rtol=2e-3

IS 0 n0 DC 0 AC 1
RL0 n0 0 0.330009
LL0 n0 n1 1.31306e-13
RL1 n1 0 0.165005
LL1 n1 n2 1.31306e-13
RL2 n2 0 0.165005
LL2 n2 n3 1.31306e-13
RL3 n3 0 0.165005
LL3 n3 n4 1.31306e-13
RL4 n4 0 0.165005
LL4 n4 n5 1.31306e-13
RL5 n5 0 0.165005
LL5 n5 n6 1.31306e-13
RL6 n6 0 0.165005
LL6 n6 n7 1.31306e-13
RL7 n7 0 0.165005
LL7 n7 n8 1.31306e-13
RL8 n8 0 0.165005
LL8 n8 n9 1.31306e-13
RL9 n9 0 0.165005
LL9 n9 n10 1.31306e-13
RL10 n10 0 0.165005
LL10 n10 n11 1.31306e-13
RL11 n11 0 0.165005
LL11 n11 n12 1.31306e-13
RL12 n12 0 0.165005
LL12 n12 n13 1.31306e-13
RL13 n13 0 0.165005
LL13 n13 n14 1.31306e-13
RL14 n14 0 0.165005
LL14 n14 n15 1.31306e-13
RL15 n15 0 0.165005
LL15 n15 n16 1.31306e-13
RL16 n16 0 0.165005
LL16 n16 n17 1.31306e-13
RL17 n17 0 0.165005
LL17 n17 n18 1.31306e-13
RL18 n18 0 0.165005
LL18 n18 n19 1.31306e-13
RL19 n19 0 0.165005
LL19 n19 n20 1.31306e-13
RL20 n20 0 0.165005
LL20 n20 n21 1.31306e-13
RL21 n21 0 0.165005
LL21 n21 n22 1.31306e-13
RL22 n22 0 0.165005
LL22 n22 n23 1.31306e-13
RL23 n23 0 0.165005
LL23 n23 n24 1.31306e-13
RL24 n24 0 0.165005
LL24 n24 n25 1.31306e-13
RL25 n25 0 0.165005
LL25 n25 n26 1.31306e-13
RL26 n26 0 0.165005
LL26 n26 n27 1.31306e-13
RL27 n27 0 0.165005
LL27 n27 n28 1.31306e-13
RL28 n28 0 0.165005
LL28 n28 n29 1.31306e-13
RL29 n29 0 0.165005
LL29 n29 n30 1.31306e-13
RL30 n30 0 0.165005
LL30 n30 n31 1.31306e-13
RL31 n31 0 0.165005
LL31 n31 n32 1.31306e-13
RL32 n32 0 0.165005
LL32 n32 n33 1.31306e-13
RL33 n33 0 0.165005
LL33 n33 n34 1.31306e-13
RL34 n34 0 0.165005
LL34 n34 n35 1.31306e-13
RL35 n35 0 0.165005
LL35 n35 n36 1.31306e-13
RL36 n36 0 0.165005
LL36 n36 n37 1.31306e-13
RL37 n37 0 0.165005
LL37 n37 n38 1.31306e-13
RL38 n38 0 0.165005
LL38 n38 n39 1.31306e-13
RL39 n39 0 0.165005
LL39 n39 n40 1.31306e-13
RL40 n40 0 0.165005
LL40 n40 n41 1.31306e-13
RL41 n41 0 0.165005
LL41 n41 n42 1.31306e-13
RL42 n42 0 0.165005
LL42 n42 n43 1.31306e-13
RL43 n43 0 0.165005
LL43 n43 n44 1.31306e-13
RL44 n44 0 0.165005
LL44 n44 n45 1.31306e-13
RL45 n45 0 0.165005
LL45 n45 n46 1.31306e-13
RL46 n46 0 0.165005
LL46 n46 n47 1.31306e-13
RL47 n47 0 0.165005
LL47 n47 n48 1.31306e-13
RL48 n48 0 0.165005
LL48 n48 n49 1.31306e-13
RL49 n49 0 0.165005
LL49 n49 n50 1.31306e-13
RL50 n50 0 0.165005
LL50 n50 n51 1.31306e-13
RL51 n51 0 0.165005
LL51 n51 n52 1.31306e-13
RL52 n52 0 0.165005
LL52 n52 n53 1.31306e-13
RL53 n53 0 0.165005
LL53 n53 n54 1.31306e-13
RL54 n54 0 0.165005
LL54 n54 n55 1.31306e-13
RL55 n55 0 0.165005
LL55 n55 n56 1.31306e-13
RL56 n56 0 0.165005
LL56 n56 n57 1.31306e-13
RL57 n57 0 0.165005
LL57 n57 n58 1.31306e-13
RL58 n58 0 0.165005
LL58 n58 n59 1.31306e-13
RL59 n59 0 0.165005
LL59 n59 n60 1.31306e-13
RL60 n60 0 0.165005
LL60 n60 n61 1.31306e-13
RL61 n61 0 0.165005
LL61 n61 n62 1.31306e-13
RL62 n62 0 0.165005
LL62 n62 n63 1.31306e-13
RL63 n63 0 0.165005
LL63 n63 n64 1.31306e-13
RL64 n64 0 0.165005
LL64 n64 n65 1.31306e-13
RL65 n65 0 0.165005
LL65 n65 n66 1.31306e-13
RL66 n66 0 0.165005
LL66 n66 n67 1.31306e-13
RL67 n67 0 0.165005
LL67 n67 n68 1.31306e-13
RL68 n68 0 0.165005
LL68 n68 n69 1.31306e-13
RL69 n69 0 0.165005
LL69 n69 n70 1.31306e-13
RL70 n70 0 0.165005
LL70 n70 n71 1.31306e-13
RL71 n71 0 0.165005
LL71 n71 n72 1.31306e-13
RL72 n72 0 0.165005
LL72 n72 n73 1.31306e-13
RL73 n73 0 0.165005
LL73 n73 n74 1.31306e-13
RL74 n74 0 0.165005
LL74 n74 n75 1.31306e-13
RL75 n75 0 0.165005
LL75 n75 n76 1.31306e-13
RL76 n76 0 0.165005
LL76 n76 n77 1.31306e-13
RL77 n77 0 0.165005
LL77 n77 n78 1.31306e-13
RL78 n78 0 0.165005
LL78 n78 n79 1.31306e-13
RL79 n79 0 0.165005
LL79 n79 n80 1.31306e-13
RL80 n80 0 0.165005
LL80 n80 n81 1.31306e-13
RL81 n81 0 0.165005
LL81 n81 n82 1.31306e-13
RL82 n82 0 0.165005
LL82 n82 n83 1.31306e-13
RL83 n83 0 0.165005
LL83 n83 n84 1.31306e-13
RL84 n84 0 0.165005
LL84 n84 n85 1.31306e-13
RL85 n85 0 0.165005
LL85 n85 n86 1.31306e-13
RL86 n86 0 0.165005
LL86 n86 n87 1.31306e-13
RL87 n87 0 0.165005
LL87 n87 n88 1.31306e-13
RL88 n88 0 0.165005
LL88 n88 n89 1.31306e-13
RL89 n89 0 0.165005
LL89 n89 n90 1.31306e-13
RL90 n90 0 0.165005
LL90 n90 n91 1.31306e-13
RL91 n91 0 0.165005
LL91 n91 n92 1.31306e-13
RL92 n92 0 0.165005
LL92 n92 n93 1.31306e-13
RL93 n93 0 0.165005
LL93 n93 n94 1.31306e-13
RL94 n94 0 0.165005
LL94 n94 n95 1.31306e-13
RL95 n95 0 0.165005
LL95 n95 n96 1.31306e-13
RL96 n96 0 0.165005
LL96 n96 n97 1.31306e-13
RL97 n97 0 0.165005
LL97 n97 n98 1.31306e-13
RL98 n98 0 0.165005
LL98 n98 n99 1.31306e-13
RL99 n99 0 0.165005
LL99 n99 n100 1.31306e-13
RL100 n100 0 0.165005
LL100 n100 n101 1.31306e-13
RL101 n101 0 0.165005
LL101 n101 n102 1.31306e-13
RL102 n102 0 0.165005
LL102 n102 n103 1.31306e-13
RL103 n103 0 0.165005
LL103 n103 n104 1.31306e-13
RL104 n104 0 0.165005
LL104 n104 n105 1.31306e-13
RL105 n105 0 0.165005
LL105 n105 n106 1.31306e-13
RL106 n106 0 0.165005
LL106 n106 n107 1.31306e-13
RL107 n107 0 0.165005
LL107 n107 n108 1.31306e-13
RL108 n108 0 0.165005
LL108 n108 n109 1.31306e-13
RL109 n109 0 0.165005
LL109 n109 n110 1.31306e-13
RL110 n110 0 0.165005
LL110 n110 n111 1.31306e-13
RL111 n111 0 0.165005
LL111 n111 n112 1.31306e-13
RL112 n112 0 0.165005
LL112 n112 n113 1.31306e-13
RL113 n113 0 0.165005
LL113 n113 n114 1.31306e-13
RL114 n114 0 0.165005
LL114 n114 n115 1.31306e-13
RL115 n115 0 0.165005
LL115 n115 n116 1.31306e-13
RL116 n116 0 0.165005
LL116 n116 n117 1.31306e-13
RL117 n117 0 0.165005
LL117 n117 n118 1.31306e-13
RL118 n118 0 0.165005
LL118 n118 n119 1.31306e-13
RL119 n119 0 0.165005
LL119 n119 n120 1.31306e-13
RL120 n120 0 0.165005
LL120 n120 n121 1.31306e-13
RL121 n121 0 0.165005
LL121 n121 n122 1.31306e-13
RL122 n122 0 0.165005
LL122 n122 n123 1.31306e-13
RL123 n123 0 0.165005
LL123 n123 n124 1.31306e-13
RL124 n124 0 0.165005
LL124 n124 n125 1.31306e-13
RL125 n125 0 0.165005
LL125 n125 n126 1.31306e-13
RL126 n126 0 0.165005
LL126 n126 n127 1.31306e-13
RL127 n127 0 0.165005
LL127 n127 n128 1.31306e-13
RL128 n128 0 0.165005
LL128 n128 n129 1.31306e-13
RL129 n129 0 0.165005
LL129 n129 n130 1.31306e-13
RL130 n130 0 0.165005
LL130 n130 n131 1.31306e-13
RL131 n131 0 0.165005
LL131 n131 n132 1.31306e-13
RL132 n132 0 0.165005
LL132 n132 n133 1.31306e-13
RL133 n133 0 0.165005
LL133 n133 n134 1.31306e-13
RL134 n134 0 0.165005
LL134 n134 n135 1.31306e-13
RL135 n135 0 0.165005
LL135 n135 n136 1.31306e-13
RL136 n136 0 0.165005
LL136 n136 n137 1.31306e-13
RL137 n137 0 0.165005
LL137 n137 n138 1.31306e-13
RL138 n138 0 0.165005
LL138 n138 n139 1.31306e-13
RL139 n139 0 0.165005
LL139 n139 n140 1.31306e-13
RL140 n140 0 0.165005
LL140 n140 n141 1.31306e-13
RL141 n141 0 0.165005
LL141 n141 n142 1.31306e-13
RL142 n142 0 0.165005
LL142 n142 n143 1.31306e-13
RL143 n143 0 0.165005
LL143 n143 n144 1.31306e-13
RL144 n144 0 0.165005
LL144 n144 n145 1.31306e-13
RL145 n145 0 0.165005
LL145 n145 n146 1.31306e-13
RL146 n146 0 0.165005
LL146 n146 n147 1.31306e-13
RL147 n147 0 0.165005
LL147 n147 n148 1.31306e-13
RL148 n148 0 0.165005
LL148 n148 n149 1.31306e-13
RL149 n149 0 0.165005
LL149 n149 n150 1.31306e-13
RL150 n150 0 0.165005
LL150 n150 n151 1.31306e-13
RL151 n151 0 0.165005
LL151 n151 n152 1.31306e-13
RL152 n152 0 0.165005
LL152 n152 n153 1.31306e-13
RL153 n153 0 0.165005
LL153 n153 n154 1.31306e-13
RL154 n154 0 0.165005
LL154 n154 n155 1.31306e-13
RL155 n155 0 0.165005
LL155 n155 n156 1.31306e-13
RL156 n156 0 0.165005
LL156 n156 n157 1.31306e-13
RL157 n157 0 0.165005
LL157 n157 n158 1.31306e-13
RL158 n158 0 0.165005
LL158 n158 n159 1.31306e-13
RL159 n159 0 0.165005
LL159 n159 n160 1.31306e-13
RL160 n160 0 0.165005
LL160 n160 n161 1.31306e-13
RL161 n161 0 0.165005
LL161 n161 n162 1.31306e-13
RL162 n162 0 0.165005
LL162 n162 n163 1.31306e-13
RL163 n163 0 0.165005
LL163 n163 n164 1.31306e-13
RL164 n164 0 0.165005
LL164 n164 n165 1.31306e-13
RL165 n165 0 0.165005
LL165 n165 n166 1.31306e-13
RL166 n166 0 0.165005
LL166 n166 n167 1.31306e-13
RL167 n167 0 0.165005
LL167 n167 n168 1.31306e-13
RL168 n168 0 0.165005
LL168 n168 n169 1.31306e-13
RL169 n169 0 0.165005
LL169 n169 n170 1.31306e-13
RL170 n170 0 0.165005
LL170 n170 n171 1.31306e-13
RL171 n171 0 0.165005
LL171 n171 n172 1.31306e-13
RL172 n172 0 0.165005
LL172 n172 n173 1.31306e-13
RL173 n173 0 0.165005
LL173 n173 n174 1.31306e-13
RL174 n174 0 0.165005
LL174 n174 n175 1.31306e-13
RL175 n175 0 0.165005
LL175 n175 n176 1.31306e-13
RL176 n176 0 0.165005
LL176 n176 n177 1.31306e-13
RL177 n177 0 0.165005
LL177 n177 n178 1.31306e-13
RL178 n178 0 0.165005
LL178 n178 n179 1.31306e-13
RL179 n179 0 0.165005
LL179 n179 n180 1.31306e-13
RL180 n180 0 0.165005
LL180 n180 n181 1.31306e-13
RL181 n181 0 0.165005
LL181 n181 n182 1.31306e-13
RL182 n182 0 0.165005
LL182 n182 n183 1.31306e-13
RL183 n183 0 0.165005
LL183 n183 n184 1.31306e-13
RL184 n184 0 0.165005
LL184 n184 n185 1.31306e-13
RL185 n185 0 0.165005
LL185 n185 n186 1.31306e-13
RL186 n186 0 0.165005
LL186 n186 n187 1.31306e-13
RL187 n187 0 0.165005
LL187 n187 n188 1.31306e-13
RL188 n188 0 0.165005
LL188 n188 n189 1.31306e-13
RL189 n189 0 0.165005
LL189 n189 n190 1.31306e-13
RL190 n190 0 0.165005
LL190 n190 n191 1.31306e-13
RL191 n191 0 0.165005
LL191 n191 n192 1.31306e-13
RL192 n192 0 0.165005
LL192 n192 n193 1.31306e-13
RL193 n193 0 0.165005
LL193 n193 n194 1.31306e-13
RL194 n194 0 0.165005
LL194 n194 n195 1.31306e-13
RL195 n195 0 0.165005
LL195 n195 n196 1.31306e-13
RL196 n196 0 0.165005
LL196 n196 n197 1.31306e-13
RL197 n197 0 0.165005
LL197 n197 n198 1.31306e-13
RL198 n198 0 0.165005
LL198 n198 n199 1.31306e-13
RL199 n199 0 0.165005
LL199 n199 n200 1.31306e-13
RL200 n200 0 0.165005
LL200 n200 n201 1.31306e-13
RL201 n201 0 0.165005
LL201 n201 n202 1.31306e-13
RL202 n202 0 0.165005
LL202 n202 n203 1.31306e-13
RL203 n203 0 0.165005
LL203 n203 n204 1.31306e-13
RL204 n204 0 0.165005
LL204 n204 n205 1.31306e-13
RL205 n205 0 0.165005
LL205 n205 n206 1.31306e-13
RL206 n206 0 0.165005
LL206 n206 n207 1.31306e-13
RL207 n207 0 0.165005
LL207 n207 n208 1.31306e-13
RL208 n208 0 0.165005
LL208 n208 n209 1.31306e-13
RL209 n209 0 0.165005
LL209 n209 n210 1.31306e-13
RL210 n210 0 0.165005
LL210 n210 n211 1.31306e-13
RL211 n211 0 0.165005
LL211 n211 n212 1.31306e-13
RL212 n212 0 0.165005
LL212 n212 n213 1.31306e-13
RL213 n213 0 0.165005
LL213 n213 n214 1.31306e-13
RL214 n214 0 0.165005
LL214 n214 n215 1.31306e-13
RL215 n215 0 0.165005
LL215 n215 n216 1.31306e-13
RL216 n216 0 0.165005
LL216 n216 n217 1.31306e-13
RL217 n217 0 0.165005
LL217 n217 n218 1.31306e-13
RL218 n218 0 0.165005
LL218 n218 n219 1.31306e-13
RL219 n219 0 0.165005
LL219 n219 n220 1.31306e-13
RL220 n220 0 0.165005
LL220 n220 n221 1.31306e-13
RL221 n221 0 0.165005
LL221 n221 n222 1.31306e-13
RL222 n222 0 0.165005
LL222 n222 n223 1.31306e-13
RL223 n223 0 0.165005
LL223 n223 n224 1.31306e-13
RL224 n224 0 0.165005
LL224 n224 n225 1.31306e-13
RL225 n225 0 0.165005
LL225 n225 n226 1.31306e-13
RL226 n226 0 0.165005
LL226 n226 n227 1.31306e-13
RL227 n227 0 0.165005
LL227 n227 n228 1.31306e-13
RL228 n228 0 0.165005
LL228 n228 n229 1.31306e-13
RL229 n229 0 0.165005
LL229 n229 n230 1.31306e-13
RL230 n230 0 0.165005
LL230 n230 n231 1.31306e-13
RL231 n231 0 0.165005
LL231 n231 n232 1.31306e-13
RL232 n232 0 0.165005
LL232 n232 n233 1.31306e-13
RL233 n233 0 0.165005
LL233 n233 n234 1.31306e-13
RL234 n234 0 0.165005
LL234 n234 n235 1.31306e-13
RL235 n235 0 0.165005
LL235 n235 n236 1.31306e-13
RL236 n236 0 0.165005
LL236 n236 n237 1.31306e-13
RL237 n237 0 0.165005
LL237 n237 n238 1.31306e-13
RL238 n238 0 0.165005
LL238 n238 n239 1.31306e-13
RL239 n239 0 0.165005
LL239 n239 n240 1.31306e-13
RL240 n240 0 0.165005

.control
ac lin 1 1e9 1e9
let zr = real(v(n0))
let zi = imag(v(n0))
print zr zi
quit
.endc
.end
