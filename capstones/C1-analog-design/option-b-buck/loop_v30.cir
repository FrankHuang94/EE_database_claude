* C1 option B: loop gain and DC output at 3.0 V input, averaged model. Generated by gen_buck.py.
* EXPECT vo1 key:results.md#B.L30.nom.lt.vo scale=1 rtol=1.0e-03
* EXPECT fc1 key:results.md#B.L30.nom.lt.fc scale=1000 rtol=1.0e-03
* EXPECT pm1 key:results.md#B.L30.nom.lt.pm scale=1 rtol=1.0e-03
* EXPECT gm1 key:results.md#B.L30.nom.lt.gm scale=1 rtol=3.2e-03
* EXPECT vo2 key:results.md#B.L30.nom.hv.vo scale=1 rtol=1.0e-03
* EXPECT fc2 key:results.md#B.L30.nom.hv.fc scale=1000 rtol=1.0e-03
* EXPECT pm2 key:results.md#B.L30.nom.hv.pm scale=1 rtol=1.0e-03
* EXPECT gm2 key:results.md#B.L30.nom.hv.gm scale=1 rtol=3.2e-03
* EXPECT vo3 key:results.md#B.L30.lmcm.lt.vo scale=1 rtol=1.0e-03
* EXPECT fc3 key:results.md#B.L30.lmcm.lt.fc scale=1000 rtol=5.5e-03
* EXPECT pm3 key:results.md#B.L30.lmcm.lt.pm scale=1 rtol=1.0e-03
* EXPECT gm3 key:results.md#B.L30.lmcm.lt.gm scale=1 rtol=4.1e-03
* EXPECT vo4 key:results.md#B.L30.lmcm.hv.vo scale=1 rtol=1.0e-03
* EXPECT fc4 key:results.md#B.L30.lmcm.hv.fc scale=1000 rtol=5.5e-03
* EXPECT pm4 key:results.md#B.L30.lmcm.hv.pm scale=1 rtol=1.0e-03
* EXPECT gm4 key:results.md#B.L30.lmcm.hv.gm scale=1 rtol=4.1e-03
* EXPECT vo5 key:results.md#B.L30.lp.lt.vo scale=1 rtol=1.0e-03
* EXPECT fc5 key:results.md#B.L30.lp.lt.fc scale=1000 rtol=1.0e-03
* EXPECT pm5 key:results.md#B.L30.lp.lt.pm scale=1 rtol=1.0e-03
* EXPECT gm5 key:results.md#B.L30.lp.lt.gm scale=1 rtol=3.0e-03
* EXPECT vo6 key:results.md#B.L30.lp.hv.vo scale=1 rtol=1.0e-03
* EXPECT fc6 key:results.md#B.L30.lp.hv.fc scale=1000 rtol=1.0e-03
* EXPECT pm6 key:results.md#B.L30.lp.hv.pm scale=1 rtol=1.0e-03
* EXPECT gm6 key:results.md#B.L30.lp.hv.gm scale=1 rtol=2.9e-03
* EXPECT vo7 key:results.md#B.L30.lm.lt.vo scale=1 rtol=1.0e-03
* EXPECT fc7 key:results.md#B.L30.lm.lt.fc scale=1000 rtol=1.0e-03
* EXPECT pm7 key:results.md#B.L30.lm.lt.pm scale=1 rtol=1.0e-03
* EXPECT gm7 key:results.md#B.L30.lm.lt.gm scale=1 rtol=3.6e-03
* EXPECT vo8 key:results.md#B.L30.lm.hv.vo scale=1 rtol=1.0e-03
* EXPECT fc8 key:results.md#B.L30.lm.hv.fc scale=1000 rtol=1.0e-03
* EXPECT pm8 key:results.md#B.L30.lm.hv.pm scale=1 rtol=1.0e-03
* EXPECT gm8 key:results.md#B.L30.lm.hv.gm scale=1 rtol=3.5e-03
* EXPECT vo9 key:results.md#B.L30.lpcm.lt.vo scale=1 rtol=1.0e-03
* EXPECT fc9 key:results.md#B.L30.lpcm.lt.fc scale=1000 rtol=1.0e-03
* EXPECT pm9 key:results.md#B.L30.lpcm.lt.pm scale=1 rtol=1.0e-03
* EXPECT gm9 key:results.md#B.L30.lpcm.lt.gm scale=1 rtol=3.4e-03
* EXPECT vo10 key:results.md#B.L30.lpcm.hv.vo scale=1 rtol=1.0e-03
* EXPECT fc10 key:results.md#B.L30.lpcm.hv.fc scale=1000 rtol=1.0e-03
* EXPECT pm10 key:results.md#B.L30.lpcm.hv.pm scale=1 rtol=1.0e-03
* EXPECT gm10 key:results.md#B.L30.lpcm.hv.gm scale=1 rtol=3.3e-03
.include buck_avg.sub

* nom.lt: L = 1 x 1 uH, C = 1 x 44 uF, 0.1 A, on-resistance x 1
Vin1 vin1 0 3.0
X1 vin1 o1 f1 buck_avg params: L=1u C=44u RHS=50m RLS=30m
Vj1 f1 o1 DC 0 AC 1
Il1 o1 0 DC 0.1

* nom.hv: L = 1 x 1 uH, C = 1 x 44 uF, 1 A, on-resistance x 1.4
Vin2 vin2 0 3.0
X2 vin2 o2 f2 buck_avg params: L=1u C=44u RHS=70m RLS=42m
Vj2 f2 o2 DC 0 AC 1
Il2 o2 0 DC 1

* lmcm.lt: L = 0.8 x 1 uH, C = 0.8 x 44 uF, 0.1 A, on-resistance x 1
Vin3 vin3 0 3.0
X3 vin3 o3 f3 buck_avg params: L=0.8u C=35.2u RHS=50m RLS=30m
Vj3 f3 o3 DC 0 AC 1
Il3 o3 0 DC 0.1

* lmcm.hv: L = 0.8 x 1 uH, C = 0.8 x 44 uF, 1 A, on-resistance x 1.4
Vin4 vin4 0 3.0
X4 vin4 o4 f4 buck_avg params: L=0.8u C=35.2u RHS=70m RLS=42m
Vj4 f4 o4 DC 0 AC 1
Il4 o4 0 DC 1

* lp.lt: L = 1.2 x 1 uH, C = 1 x 44 uF, 0.1 A, on-resistance x 1
Vin5 vin5 0 3.0
X5 vin5 o5 f5 buck_avg params: L=1.2u C=44u RHS=50m RLS=30m
Vj5 f5 o5 DC 0 AC 1
Il5 o5 0 DC 0.1

* lp.hv: L = 1.2 x 1 uH, C = 1 x 44 uF, 1 A, on-resistance x 1.4
Vin6 vin6 0 3.0
X6 vin6 o6 f6 buck_avg params: L=1.2u C=44u RHS=70m RLS=42m
Vj6 f6 o6 DC 0 AC 1
Il6 o6 0 DC 1

* lm.lt: L = 0.8 x 1 uH, C = 1 x 44 uF, 0.1 A, on-resistance x 1
Vin7 vin7 0 3.0
X7 vin7 o7 f7 buck_avg params: L=0.8u C=44u RHS=50m RLS=30m
Vj7 f7 o7 DC 0 AC 1
Il7 o7 0 DC 0.1

* lm.hv: L = 0.8 x 1 uH, C = 1 x 44 uF, 1 A, on-resistance x 1.4
Vin8 vin8 0 3.0
X8 vin8 o8 f8 buck_avg params: L=0.8u C=44u RHS=70m RLS=42m
Vj8 f8 o8 DC 0 AC 1
Il8 o8 0 DC 1

* lpcm.lt: L = 1.2 x 1 uH, C = 0.8 x 44 uF, 0.1 A, on-resistance x 1
Vin9 vin9 0 3.0
X9 vin9 o9 f9 buck_avg params: L=1.2u C=35.2u RHS=50m RLS=30m
Vj9 f9 o9 DC 0 AC 1
Il9 o9 0 DC 0.1

* lpcm.hv: L = 1.2 x 1 uH, C = 0.8 x 44 uF, 1 A, on-resistance x 1.4
Vin10 vin10 0 3.0
X10 vin10 o10 f10 buck_avg params: L=1.2u C=35.2u RHS=70m RLS=42m
Vj10 f10 o10 DC 0 AC 1
Il10 o10 0 DC 1

.control
op
let vo1 = v(o1)
let vo2 = v(o2)
let vo3 = v(o3)
let vo4 = v(o4)
let vo5 = v(o5)
let vo6 = v(o6)
let vo7 = v(o7)
let vo8 = v(o8)
let vo9 = v(o9)
let vo10 = v(o10)
print vo1 vo2 vo3 vo4 vo5 vo6 vo7 vo8 vo9 vo10
ac dec 200 100 10Meg
let t1 = -v(o1)/v(f1)
let tdb1 = db(t1)
let tph1 = 180/pi*cph(t1)
meas ac fc1 when tdb1=0
meas ac phc1 find tph1 at=fc1
meas ac fx1 when tph1=-180 cross=last
meas ac gx1 find tdb1 at=fx1
let pm1 = 180 + phc1
let gm1 = -gx1
print pm1 gm1
let t2 = -v(o2)/v(f2)
let tdb2 = db(t2)
let tph2 = 180/pi*cph(t2)
meas ac fc2 when tdb2=0
meas ac phc2 find tph2 at=fc2
meas ac fx2 when tph2=-180 cross=last
meas ac gx2 find tdb2 at=fx2
let pm2 = 180 + phc2
let gm2 = -gx2
print pm2 gm2
let t3 = -v(o3)/v(f3)
let tdb3 = db(t3)
let tph3 = 180/pi*cph(t3)
meas ac fc3 when tdb3=0
meas ac phc3 find tph3 at=fc3
meas ac fx3 when tph3=-180 cross=last
meas ac gx3 find tdb3 at=fx3
let pm3 = 180 + phc3
let gm3 = -gx3
print pm3 gm3
let t4 = -v(o4)/v(f4)
let tdb4 = db(t4)
let tph4 = 180/pi*cph(t4)
meas ac fc4 when tdb4=0
meas ac phc4 find tph4 at=fc4
meas ac fx4 when tph4=-180 cross=last
meas ac gx4 find tdb4 at=fx4
let pm4 = 180 + phc4
let gm4 = -gx4
print pm4 gm4
let t5 = -v(o5)/v(f5)
let tdb5 = db(t5)
let tph5 = 180/pi*cph(t5)
meas ac fc5 when tdb5=0
meas ac phc5 find tph5 at=fc5
meas ac fx5 when tph5=-180 cross=last
meas ac gx5 find tdb5 at=fx5
let pm5 = 180 + phc5
let gm5 = -gx5
print pm5 gm5
let t6 = -v(o6)/v(f6)
let tdb6 = db(t6)
let tph6 = 180/pi*cph(t6)
meas ac fc6 when tdb6=0
meas ac phc6 find tph6 at=fc6
meas ac fx6 when tph6=-180 cross=last
meas ac gx6 find tdb6 at=fx6
let pm6 = 180 + phc6
let gm6 = -gx6
print pm6 gm6
let t7 = -v(o7)/v(f7)
let tdb7 = db(t7)
let tph7 = 180/pi*cph(t7)
meas ac fc7 when tdb7=0
meas ac phc7 find tph7 at=fc7
meas ac fx7 when tph7=-180 cross=last
meas ac gx7 find tdb7 at=fx7
let pm7 = 180 + phc7
let gm7 = -gx7
print pm7 gm7
let t8 = -v(o8)/v(f8)
let tdb8 = db(t8)
let tph8 = 180/pi*cph(t8)
meas ac fc8 when tdb8=0
meas ac phc8 find tph8 at=fc8
meas ac fx8 when tph8=-180 cross=last
meas ac gx8 find tdb8 at=fx8
let pm8 = 180 + phc8
let gm8 = -gx8
print pm8 gm8
let t9 = -v(o9)/v(f9)
let tdb9 = db(t9)
let tph9 = 180/pi*cph(t9)
meas ac fc9 when tdb9=0
meas ac phc9 find tph9 at=fc9
meas ac fx9 when tph9=-180 cross=last
meas ac gx9 find tdb9 at=fx9
let pm9 = 180 + phc9
let gm9 = -gx9
print pm9 gm9
let t10 = -v(o10)/v(f10)
let tdb10 = db(t10)
let tph10 = 180/pi*cph(t10)
meas ac fc10 when tdb10=0
meas ac phc10 find tph10 at=fc10
meas ac fx10 when tph10=-180 cross=last
meas ac gx10 find tdb10 at=fx10
let pm10 = 180 + phc10
let gm10 = -gx10
print pm10 gm10
.endc
.end
