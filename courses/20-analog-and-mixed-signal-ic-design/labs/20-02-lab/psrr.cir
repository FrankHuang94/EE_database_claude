* Lab 20-02 -- negative-supply rejection of Example 20-02.3's op-amp (section 3.10's two-node model) as a unity-gain
* follower. VSS carries a 1 V AC ripple; M6's transconductance acts on v(n1) - v(vss), its r_o6 = 4 V / I_6 =
* 25.672 kohm returns to VSS, node 1's R1 = 381.972 kohm and C1 = 110.729 fF return to VSS (the mirror and M6's
* gate-source capacitance), and r_o7 = 25.672 kohm and CL = 2 pF return to a clean ground. The first stage's current
* is g_m1 (0 - v(out)): the non-inverting input is at (AC) ground and the output is fed back to the inverting input.
* Cc = 0.6 pF (the nulling resistor is omitted, as in the chapter's model). The ripple reaching the output, in dB
* below the ripple, is the follower's supply rejection A_ss/(1 + A_dm), close to the open-loop PSRR when A_dm >> 1.
*
* EXPECT rej1k key:README.md#Lab_20-02.e rtol=1e-3
* EXPECT rej1m key:README.md#Lab_20-02.f rtol=1e-3

VSS vss 0 DC 0 AC 1
G1 n1 0 0 out 188.4956u
R1 n1 vss 381.972k
C1 n1 vss 110.729f
CC n1 out 0.6p
G6 out vss n1 vss 1.558121m
RO6 out vss 25.6719k
RO7 out 0 25.6719k
CL out 0 2p

.control
ac dec 100 10 100Meg
let rej = -db(v(out))
meas ac rej1k find rej at=1k
meas ac rej1m find rej at=1Meg
print rej1k rej1m
.endc
.end
