* Example 07-08.6: a fourth-order Butterworth band-pass ladder (2 GHz, 20 MHz wide, 50 ohm) with every
* resonator at Qu = 200 (series resistance in series resonators, parallel resistance in shunt ones);
* insertion loss = -20 lg(2 V_out / V_s) at 2 GHz.
* Example 07-08.7: the voice-band cascade, a unity-gain Sallen-Key high-pass (300 Hz, C = 100 nF) into an
* MFB low-pass (3.4 kHz, R = 10 k); op-amps as voltage-controlled sources.
*
* EXPECT il6  key:../../chapters/07-08-filters-and-resonance.md#Ex_07-08.6f rtol=5e-4
* EXPECT g50  key:../../chapters/07-08-filters-and-resonance.md#Ex_07-08.7e rtol=2e-4
* EXPECT g1k  key:../../chapters/07-08-filters-and-resonance.md#Ex_07-08.7g rtol=2e-3
* EXPECT g34  key:../../chapters/07-08-filters-and-resonance.md#Ex_07-08.7h rtol=2e-4
* EXPECT g20  key:../../chapters/07-08-filters-and-resonance.md#Ex_07-08.7i rtol=2e-4

* ---- Example 07-08.6
Vs  s 0 AC 1
Rg  s n0 50
C0 n0 0 1.218119198e-10
L0 n0 0 5.198648858e-11
Rp0 n0 0 1.306562965e+02
Rs1 n0 r1 4.619397663e+01
L1 r1 m1 7.351999721e-07
C1 m1 n1 8.613403452e-15
C2 n1 0 2.940799888e-10
L2 n1 0 2.153350863e-11
Rp2 n1 0 5.411961001e+01
Rs3 n1 r3 1.913417162e+01
L3 r3 m3 3.045297995e-07
C3 m3 n3 2.079459543e-14
RL  n3 0 50
* ---- Example 07-08.7
Vin in 0 AC 1
Ch1 in A 100n
Ch2 A B 100n
Rh2 B 0 7.502636k
Rh1 A h 3.751318k
Eh  h 0 B 0 1
Rm1 h P 10k
Cm1 P 0 9.929959n
Rm2 P out 10k
Rm3 P N 10k
Cm2 N out 2.206658n
Em  out 0 0 N 1e8

.control
ac lin 1 2G 2G
let il6 = -db(2*v(n3))
print il6
ac lin 1 50 50
let g50 = vdb(out)
print g50
ac lin 1 1k 1k
let g1k = vdb(out)
print g1k
ac lin 1 3.4k 3.4k
let g34 = vdb(out)
print g34
ac lin 1 20k 20k
let g20 = vdb(out)
print g20
.endc
.end
