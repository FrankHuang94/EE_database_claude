* Example 01-06.5 and Problem 01-06.10 -- noise bandwidth and kT/C, by ngspice noise analysis.
* .noise integrates the output noise spectral density over frequency (onoise_total).
* Circuit 1: 10 kOhm with C chosen for fc = 10 kHz -> sqrt(4kTR * (pi/2) fc) = 1.613 uV.
* Circuit 2: 1 kOhm and 1 pF -> sqrt(kT/C) = 64.36 uV.
* Circuit 3: 1 MOhm and 1 pF -> the same 64.36 uV: kT/C does not depend on R.
* T = 300 K.
*
* EXPECT vn1 key:../../chapters/01-06-techniques-of-integration.md#Ex_01-06.5c scale=1e-6 rtol=1e-3
* EXPECT vn2 key:../../solutions/01-06-solutions.md#01-06.10d scale=1e-6 rtol=1e-3
* EXPECT vn3 key:README.md#Lab_01-06.a scale=1e-6 rtol=1e-3

.options temp=26.85 tnom=26.85
V1 in1 0 DC 0 AC 1
R1 in1 o1 10k
C1 o1  0  1.5915494n
V2 in2 0 DC 0 AC 1
R2 in2 o2 1k
C2 o2  0  1p
V3 in3 0 DC 0 AC 1
R3 in3 o3 1meg
C3 o3  0  1p

.control
noise v(o1) V1 dec 100 1 1e9
setplot noise2
echo "vn1 = $&onoise_total"
noise v(o2) V2 dec 100 1 1e12
setplot noise4
echo "vn2 = $&onoise_total"
noise v(o3) V3 dec 100 1 1e12
setplot noise6
echo "vn3 = $&onoise_total"
.endc
.end
