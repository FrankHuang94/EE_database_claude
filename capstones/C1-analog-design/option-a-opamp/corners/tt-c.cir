* C1 option A, corner TT-C: process TT, -40 degC, VDD = 1.98 V. Generated by gen_corners.py.
* EXPECT a0 key:../results.md#A.TT-C.a0 scale=1 rtol=1.0e-03
* EXPECT ugf key:../results.md#A.TT-C.ugf scale=1e+06 rtol=1.2e-03
* EXPECT pm key:../results.md#A.TT-C.pm scale=1 rtol=1.0e-03
* EXPECT srr key:../results.md#A.TT-C.srr scale=1 rtol=2.4e-03
* EXPECT srf key:../results.md#A.TT-C.srf scale=1 rtol=2.5e-03
* EXPECT pwr key:../results.md#A.TT-C.pwr scale=1e-06 rtol=1.4e-03
* EXPECT outhi key:../results.md#A.TT-C.outhi scale=1 rtol=1.0e-03
* EXPECT outlo key:../results.md#A.TT-C.outlo scale=1 rtol=1.0e-03
* EXPECT m5mar key:../results.md#A.TT-C.m5mar scale=0.001 rtol=4.4e-03
* EXPECT gm1 key:../results.md#A.TT-C.gm1 scale=1e-06 rtol=1.2e-03
* EXPECT gm6 key:../results.md#A.TT-C.gm6 scale=0.001 rtol=2.9e-03
.lib '../../models/c1_process.lib' tt
.include ../opamp.sub
.temp -40

* A: open-loop response
VDDA vdda 0 1.98
IRA vdda iba 20u
VINA pa 0 DC 0.9 AC 1
XA pa na oa vdda 0 iba opamp
LFA oa na 1G
CFA na 0 1
CLA oa 0 2p

* B: unity-gain follower, slew rate
VDDB vddb 0 1.98
IRB vddb ibb 20u
VSB pb 0 PULSE(0.6 1.2 100n 1n 1n 400n 800n)
XB pb ob ob vddb 0 ibb opamp
CLB ob 0 2p

* C: inverting gain of -1 about 0.9 V, output range
VDDC vddc 0 1.98
IRC vddc ibc 20u
VRC rc 0 0.9
VSC sc 0 0.9
R1C sc nc 100k
R2C nc oc 100k
XC rc nc oc vddc 0 ibc opamp
CLC oc 0 2p

.control
op
let pwr = -i(vdda) * 1.98
let m5mar = @m.xa.m5[vds] - @m.xa.m5[vdsat]
let gm1 = @m.xa.m1[gm]
let gm6 = @m.xa.m6[gm]
print pwr m5mar gm1 gm6
ac dec 50 1 10G
meas ac a0 find vdb(oa) at=10
meas ac ugf when vdb(oa)=0
meas ac pha find vp(oa) at=ugf
let pm = 180 + pha * 180 / pi
print pm
tran 0.1n 1000n
meas tran tr1 when v(ob)=0.72 rise=1
meas tran tr2 when v(ob)=1.08 rise=1
meas tran tf1 when v(ob)=1.08 fall=1
meas tran tf2 when v(ob)=0.72 fall=1
let srr = 0.36 / (tr2 - tr1) / 1e6
let srf = 0.36 / (tf2 - tf1) / 1e6
print srr srf
dc vsc -0.6 2.2 0.001
let gcl = -deriv(v(oc))
meas dc va when gcl=0.99 rise=1
meas dc vb when gcl=0.99 fall=1
let outhi = 1.8 - va
let outlo = 1.8 - vb
print outhi outlo
.endc
.end
