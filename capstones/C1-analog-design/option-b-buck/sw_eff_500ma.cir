* C1 option B: efficiency and regulation at 3.6 V, 0.5 A, switching model. Generated by gen_buck.py.
* EXPECT vo key:results.md#B.E.500mA.vo scale=1 rtol=1.0e-03
* EXPECT eta key:results.md#B.E.500mA.eta scale=1 rtol=1.0e-03
.include buck_sw.sub
Vramp ramp 0 PULSE(0 1 0 498n 2n 0 500n)
.options reltol=1e-4

Vin1 vin1 0 3.6
X1 vin1 o1 o1 ramp buck_sw
Rl1 o1 0 2.4

.control
tran 1n 300u 0 2n uic
meas tran vo avg v(o1) from=250u to=300u
meas tran ii avg i(vin1) from=250u to=300u
let eta = 100 * (vo*vo/2.4) / (-ii*3.6)
print eta
.endc
.end
