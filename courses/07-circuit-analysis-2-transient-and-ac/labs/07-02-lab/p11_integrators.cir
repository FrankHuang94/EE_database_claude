* Problem 07-02.11 -- ideal and leaky inverting integrators, op-amp modeled as a VCVS with gain 1e6.
* Input steps from 0 to -1 V at t = 0. R = 10 kOhm, C = 100 nF; leaky version adds Rf = 100 kOhm.
*
* EXPECT vout_ideal_5m key:../../solutions/07-02-solutions.md#07-02.11a rtol=1e-3
* EXPECT vout_leaky_10m key:../../solutions/07-02-solutions.md#07-02.11c rtol=1e-3

VIN  in 0 PWL(0 0 1n -1)
* ideal integrator
R1   in n1 10k
C1   n1 o1 100n IC=0
E1   o1 0 0 n1 1e6
* leaky integrator
R2   in n2 10k
C2   n2 o2 100n IC=0
RF   n2 o2 100k
E2   o2 0 0 n2 1e6

.tran 10u 50m 0 10u UIC
.meas tran vout_ideal_5m  FIND v(o1) AT=5m
.meas tran vout_leaky_10m FIND v(o2) AT=10m
.end
