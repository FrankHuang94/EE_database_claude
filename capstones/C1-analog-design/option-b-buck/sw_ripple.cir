* C1 option B: ripple and peak current at 4.2 V, 1 A, L -20%, C -20%, switching model. Generated by gen_buck.py.
* EXPECT vo key:results.md#B.R.vo scale=1 rtol=1.0e-03
* EXPECT rip key:results.md#B.R.rip scale=0.001 rtol=4.9e-03
* EXPECT ipk key:results.md#B.R.ipk scale=1 rtol=4.7e-03
* EXPECT ivl key:results.md#B.R.ivl scale=1 rtol=1.0e-03
.include buck_sw.sub
Vramp ramp 0 PULSE(0 1 0 498n 2n 0 500n)
.options reltol=1e-4

Vin1 vin1 0 4.2
X1 vin1 o1 o1 ramp buck_sw params: L=0.8u C=35.2u
Rl1 o1 0 1.2

.control
tran 1n 300u 0 2n uic
meas tran vo avg v(o1) from=250u to=300u
meas tran vx max v(o1) from=299.5u to=300u
meas tran vn min v(o1) from=299.5u to=300u
let rip = vx - vn
meas tran ipk max i(v.x1.vil) from=299.5u to=300u
meas tran ivl min i(v.x1.vil) from=299.5u to=300u
print rip
.endc
.end
