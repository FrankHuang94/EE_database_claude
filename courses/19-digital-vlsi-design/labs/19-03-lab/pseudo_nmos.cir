* Lab 19-03: pseudo-NMOS inverter (Example 19-03.3), SPICE level-1 model
* kn = 200 uA/V^2, load PMOS kp = 50 uA/V^2 with its gate grounded, VTN = |VTP| = 0.35 V, VDD = 1.2 V
* EXPECT vol key:../../chapters/19-03-logic-families.md#Ex_19-03.3a rtol=4e-3
* EXPECT iload key:../../chapters/19-03-logic-families.md#Ex_19-03.3b scale=1e-6 rtol=3e-3

VDD vdd 0 DC 1.2
VIN in 0 DC 1.2
* a 0 V source measures the load current (positive from vdd into ps)
VSENSE vdd ps DC 0
MP out 0 ps vdd pm W=1u L=1u
MN out in 0 0 nm W=1u L=1u
.model nm NMOS (LEVEL=1 KP=200u VTO=0.35 LAMBDA=0)
.model pm PMOS (LEVEL=1 KP=50u VTO=-0.35 LAMBDA=0)
.dc VIN 1.1 1.3 0.01
.meas dc vol FIND v(out) AT=1.2
.meas dc iload FIND i(VSENSE) AT=1.2
.end
