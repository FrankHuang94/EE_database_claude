* Lab 19-11: a zero-skew merge (Problem 19-11.7), checked by Elmore constants
* Subtree 1: 10 ps and 40 fF, modeled as 250 ohm into 40 fF; subtree 2: 12 ps and 60 fF, 200 ohm into 60 fF.
* A 500 um wire (0.30 ohm/um, 0.20 fF/um) is driven at the zero-skew tap, 308.3333 um from subtree 1.
* Each side of the tap is a 40-section pi ladder, whose Elmore constant equals the continuous wire's.
* The Elmore constant to a sink is the area above its unit-step response: INTEG of 1 - v(sink).
* EXPECT elm1 key:../../solutions/19-11-solutions.md#19-11.7b scale=1e-12 rtol=1e-3
* EXPECT elm2 key:../../solutions/19-11-solutions.md#19-11.7b scale=1e-12 rtol=1e-3
Vin tap 0 PWL(0 0 1f 1)
Ra0 tap a1 2.3125
Ra1 a1 a2 2.3125
Ra2 a2 a3 2.3125
Ra3 a3 a4 2.3125
Ra4 a4 a5 2.3125
Ra5 a5 a6 2.3125
Ra6 a6 a7 2.3125
Ra7 a7 a8 2.3125
Ra8 a8 a9 2.3125
Ra9 a9 a10 2.3125
Ra10 a10 a11 2.3125
Ra11 a11 a12 2.3125
Ra12 a12 a13 2.3125
Ra13 a13 a14 2.3125
Ra14 a14 a15 2.3125
Ra15 a15 a16 2.3125
Ra16 a16 a17 2.3125
Ra17 a17 a18 2.3125
Ra18 a18 a19 2.3125
Ra19 a19 a20 2.3125
Ra20 a20 a21 2.3125
Ra21 a21 a22 2.3125
Ra22 a22 a23 2.3125
Ra23 a23 a24 2.3125
Ra24 a24 a25 2.3125
Ra25 a25 a26 2.3125
Ra26 a26 a27 2.3125
Ra27 a27 a28 2.3125
Ra28 a28 a29 2.3125
Ra29 a29 a30 2.3125
Ra30 a30 a31 2.3125
Ra31 a31 a32 2.3125
Ra32 a32 a33 2.3125
Ra33 a33 a34 2.3125
Ra34 a34 a35 2.3125
Ra35 a35 a36 2.3125
Ra36 a36 a37 2.3125
Ra37 a37 a38 2.3125
Ra38 a38 a39 2.3125
Ra39 a39 r1 2.3125
Ca_a1 a1 0 1.54166667e-15
Ca_a2 a2 0 1.54166667e-15
Ca_a3 a3 0 1.54166667e-15
Ca_a4 a4 0 1.54166667e-15
Ca_a5 a5 0 1.54166667e-15
Ca_a6 a6 0 1.54166667e-15
Ca_a7 a7 0 1.54166667e-15
Ca_a8 a8 0 1.54166667e-15
Ca_a9 a9 0 1.54166667e-15
Ca_a10 a10 0 1.54166667e-15
Ca_a11 a11 0 1.54166667e-15
Ca_a12 a12 0 1.54166667e-15
Ca_a13 a13 0 1.54166667e-15
Ca_a14 a14 0 1.54166667e-15
Ca_a15 a15 0 1.54166667e-15
Ca_a16 a16 0 1.54166667e-15
Ca_a17 a17 0 1.54166667e-15
Ca_a18 a18 0 1.54166667e-15
Ca_a19 a19 0 1.54166667e-15
Ca_a20 a20 0 1.54166667e-15
Ca_a21 a21 0 1.54166667e-15
Ca_a22 a22 0 1.54166667e-15
Ca_a23 a23 0 1.54166667e-15
Ca_a24 a24 0 1.54166667e-15
Ca_a25 a25 0 1.54166667e-15
Ca_a26 a26 0 1.54166667e-15
Ca_a27 a27 0 1.54166667e-15
Ca_a28 a28 0 1.54166667e-15
Ca_a29 a29 0 1.54166667e-15
Ca_a30 a30 0 1.54166667e-15
Ca_a31 a31 0 1.54166667e-15
Ca_a32 a32 0 1.54166667e-15
Ca_a33 a33 0 1.54166667e-15
Ca_a34 a34 0 1.54166667e-15
Ca_a35 a35 0 1.54166667e-15
Ca_a36 a36 0 1.54166667e-15
Ca_a37 a37 0 1.54166667e-15
Ca_a38 a38 0 1.54166667e-15
Ca_a39 a39 0 1.54166667e-15
Ca_r1 r1 0 7.70833333e-16
Rb0 tap b1 1.4375
Rb1 b1 b2 1.4375
Rb2 b2 b3 1.4375
Rb3 b3 b4 1.4375
Rb4 b4 b5 1.4375
Rb5 b5 b6 1.4375
Rb6 b6 b7 1.4375
Rb7 b7 b8 1.4375
Rb8 b8 b9 1.4375
Rb9 b9 b10 1.4375
Rb10 b10 b11 1.4375
Rb11 b11 b12 1.4375
Rb12 b12 b13 1.4375
Rb13 b13 b14 1.4375
Rb14 b14 b15 1.4375
Rb15 b15 b16 1.4375
Rb16 b16 b17 1.4375
Rb17 b17 b18 1.4375
Rb18 b18 b19 1.4375
Rb19 b19 b20 1.4375
Rb20 b20 b21 1.4375
Rb21 b21 b22 1.4375
Rb22 b22 b23 1.4375
Rb23 b23 b24 1.4375
Rb24 b24 b25 1.4375
Rb25 b25 b26 1.4375
Rb26 b26 b27 1.4375
Rb27 b27 b28 1.4375
Rb28 b28 b29 1.4375
Rb29 b29 b30 1.4375
Rb30 b30 b31 1.4375
Rb31 b31 b32 1.4375
Rb32 b32 b33 1.4375
Rb33 b33 b34 1.4375
Rb34 b34 b35 1.4375
Rb35 b35 b36 1.4375
Rb36 b36 b37 1.4375
Rb37 b37 b38 1.4375
Rb38 b38 b39 1.4375
Rb39 b39 r2 1.4375
Cb_b1 b1 0 9.58333333e-16
Cb_b2 b2 0 9.58333333e-16
Cb_b3 b3 0 9.58333333e-16
Cb_b4 b4 0 9.58333333e-16
Cb_b5 b5 0 9.58333333e-16
Cb_b6 b6 0 9.58333333e-16
Cb_b7 b7 0 9.58333333e-16
Cb_b8 b8 0 9.58333333e-16
Cb_b9 b9 0 9.58333333e-16
Cb_b10 b10 0 9.58333333e-16
Cb_b11 b11 0 9.58333333e-16
Cb_b12 b12 0 9.58333333e-16
Cb_b13 b13 0 9.58333333e-16
Cb_b14 b14 0 9.58333333e-16
Cb_b15 b15 0 9.58333333e-16
Cb_b16 b16 0 9.58333333e-16
Cb_b17 b17 0 9.58333333e-16
Cb_b18 b18 0 9.58333333e-16
Cb_b19 b19 0 9.58333333e-16
Cb_b20 b20 0 9.58333333e-16
Cb_b21 b21 0 9.58333333e-16
Cb_b22 b22 0 9.58333333e-16
Cb_b23 b23 0 9.58333333e-16
Cb_b24 b24 0 9.58333333e-16
Cb_b25 b25 0 9.58333333e-16
Cb_b26 b26 0 9.58333333e-16
Cb_b27 b27 0 9.58333333e-16
Cb_b28 b28 0 9.58333333e-16
Cb_b29 b29 0 9.58333333e-16
Cb_b30 b30 0 9.58333333e-16
Cb_b31 b31 0 9.58333333e-16
Cb_b32 b32 0 9.58333333e-16
Cb_b33 b33 0 9.58333333e-16
Cb_b34 b34 0 9.58333333e-16
Cb_b35 b35 0 9.58333333e-16
Cb_b36 b36 0 9.58333333e-16
Cb_b37 b37 0 9.58333333e-16
Cb_b38 b38 0 9.58333333e-16
Cb_b39 b39 0 9.58333333e-16
Cb_r2 r2 0 4.79166667e-16
Rs1 r1 s1 250
Cs1 s1 0 40f
Rs2 r2 s2 200
Cs2 s2 0 60f
Be1 e1 0 V=1-V(s1)
Be2 e2 0 V=1-V(s2)
.tran 0.02p 600p
.meas tran elm1 INTEG V(e1) FROM=0 TO=600p
.meas tran elm2 INTEG V(e2) FROM=0 TO=600p
.end
