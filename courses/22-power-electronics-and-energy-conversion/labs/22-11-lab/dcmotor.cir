* Lab 22-11, Part 1 -- Example 22-11.1's 24 V PM DC motor (Ra = 0.5 ohm, La = 1 mH, k = 0.05 V s/rad) starting
* a 0.5 N m load with rotor inertia J = 1e-4 kg m^2. The speed is the voltage on a capacitor of value J driven by
* the net torque (k i - T_load); the back EMF is a behavioral source k*omega. The load torque is applied only once
* the motor turns (a smooth step over the first 1 rad/s) so that it never drives the rotor backwards.
* EXPECT wfin key:../../chapters/22-11-electric-machines.md#Ex_22-11.1g scale=0.104719755 rtol=1e-3
* EXPECT ifin key:../../chapters/22-11-electric-machines.md#Ex_22-11.1e rtol=1e-3
* EXPECT ipk key:README.md#Lab_22-11.a rtol=5e-3
* EXPECT t63 key:README.md#Lab_22-11.b scale=1e-3 rtol=5e-3
.param V=24 Ra=0.5 La=1m K=0.05 J=1e-4 TL=0.5
Vs in 0 dc {V}
Ra in a {Ra}
La a b {La}
Bemf b 0 V = {K}*V(w)
Bt 0 w I = {K}*I(Bemf) - {TL}*min(1, max(0, V(w)))
Cj w 0 {J}
.ic v(w)=0
.control
tran 10u 0.2 0 10u uic
let ia = i(Bemf)
meas tran wfin find v(w) at=0.2
meas tran ifin find ia at=0.2
meas tran ipk max ia
meas tran t63 when v(w)=239.4
.endc
.end
