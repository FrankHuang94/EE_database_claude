* Lab 20-05 -- regeneration of a cross-coupled latch with current-limited transconductors (chapter section 3.7,
* Example 20-05.7). Each node has C = 60 fF to ground and receives i = I_max tanh(-g_m v_other/I_max) from the
* opposite node's transconductor, with g_m = 3 mS and I_max = 0.3 mA, so the small-signal time constant is
* tau = C/g_m = 20 ps. Three copies start from differential imbalances v_0 = A_int v_in for v_in = 195.3125 uV
* (half an LSB), 1 mV and 10 mV with A_int = 6.75; each measures when v(x) - v(y) reaches V_L = 0.6 V. The
* exponential estimate tau ln(V_L/v_0) is a lower bound: the transconductors saturate as the swing grows.
*
* EXPECT ta key:README.md#Lab_20-05.a scale=1e-12 rtol=2e-3
* EXPECT tb key:README.md#Lab_20-05.b scale=1e-12 rtol=2e-3
* EXPECT tc key:README.md#Lab_20-05.c scale=1e-12 rtol=2e-3

.param gm=3m imax=0.3m
BXA 0 xa I = imax*tanh(-gm*V(ya)/imax)
BYA 0 ya I = imax*tanh(-gm*V(xa)/imax)
CXA xa 0 60f
CYA ya 0 60f
BXB 0 xb I = imax*tanh(-gm*V(yb)/imax)
BYB 0 yb I = imax*tanh(-gm*V(xb)/imax)
CXB xb 0 60f
CYB yb 0 60f
BXC 0 xc I = imax*tanh(-gm*V(yc)/imax)
BYC 0 yc I = imax*tanh(-gm*V(xc)/imax)
CXC xc 0 60f
CYC yc 0 60f
.ic V(xa)=0.6591796875m V(ya)=-0.6591796875m V(xb)=3.375m V(yb)=-3.375m V(xc)=33.75m V(yc)=-33.75m
.options reltol=1e-7 abstol=1e-15 vntol=1e-10

.control
tran 0.05p 400p 0 0.05p uic
let vda = v(xa) - v(ya)
let vdb = v(xb) - v(yb)
let vdc = v(xc) - v(yc)
meas tran ta when vda=0.6 rise=1
meas tran tb when vdb=0.6 rise=1
meas tran tc when vdc=0.6 rise=1
print ta tb tc
.endc
.end
