* Lab 10-10 (more) -- three more circuits of chapter 10-10, each built from behavioral parts.
* (1) Example 10-10.3: an integrator with R = 10 kOhm and C = 10 nF.
*     (a) With a finite-gain op-amp (VCVS, A_0 = 1e5), find the -3 dB point of the lossy integrator.
*     (b) With 1 mV of offset in series with the + input, find the slope of the output ramp over the first millisecond.
*     (c) Add a 1 MOhm leak resistor and use an ideal op-amp: DC gain, output offset and the new corner.
* (2) Example 10-10.5: the non-inverting Schmitt trigger (R_1 = 2 kOhm, R_2 = 100 kOhm, V_ref = 2.5 V, output 0 or 5 V).
*     A slow triangle input finds the two switching points.
* (3) Example 10-10.8: the relaxation oscillator on +/-5 V (R = 47 kOhm, C = 10 nF, R_1 = R_2): its frequency and capacitor swing.
* Each comparator is a tanh B-source (gain 1e6 near the switching point) followed by a 10 ns RC and a unity buffer, so it is
* much faster than the circuits and its output level does not sag under load.
*
* EXPECT f3lossy key:../../chapters/10-10-op-amp-application-circuits.md#Ex_10-10.3a rtol=3e-3
* EXPECT ramp key:../../chapters/10-10-op-amp-application-circuits.md#Ex_10-10.3b rtol=2e-3
* EXPECT gdc key:../../chapters/10-10-op-amp-application-circuits.md#Ex_10-10.3d rtol=1e-3
* EXPECT voff key:../../chapters/10-10-op-amp-application-circuits.md#Ex_10-10.3e scale=1e-3 rtol=1e-3
* EXPECT f3leak key:../../chapters/10-10-op-amp-application-circuits.md#Ex_10-10.3f rtol=3e-3
* EXPECT vup key:../../chapters/10-10-op-amp-application-circuits.md#Ex_10-10.5b rtol=1e-3
* EXPECT vlo key:../../chapters/10-10-op-amp-application-circuits.md#Ex_10-10.5c rtol=1e-3
* EXPECT fosc key:../../chapters/10-10-op-amp-application-circuits.md#Ex_10-10.8b rtol=1e-4
* EXPECT vcpk key:../../chapters/10-10-op-amp-application-circuits.md#Ex_10-10.8d rtol=1e-3

* (1a) lossy integrator: A_0 = 1e5, AC input
VIA ia 0 DC 0 AC 1
RA ia na 10k
CA na oa 10n
EA oa 0 0 na 1e5

* (1b) offset ramp: input grounded, 1 mV in series with the + input, capacitor starts discharged (the output starts at V_OS
*      and then ramps, so the slope is taken between 1 ms and 2 ms)
RB 0 nb 10k
CB nb ob 10n IC=0
VOSB pb 0 DC 1m
EB ob 0 pb nb 1e5

* (1c) leak resistor, ideal op-amp: offset only (DC), and signal only (DC and AC)
RC1 0 nc 10k
CC1 nc oc 10n
RFC1 nc oc 1Meg
VOSC pc 0 DC 1m
EC1 oc 0 pc nc 1e9
VID id 0 DC 1m AC 1
RC2 id nd 10k
CC2 nd od 10n
RFC2 nd od 1Meg
EC2 od 0 0 nd 1e9

* (2) Schmitt trigger: triangle from 2.3 V to 2.7 V and back, 1 ms each way
VIN sin 0 PWL(0 2.3 1m 2.7 2m 2.3)
VREF ref 0 DC 2.5
RS1 sin sp 2k
RS2 so sp 100k
BS sx 0 V = 2.5 + 2.5*tanh(1e6*(V(sp) - V(ref)))
RSX sx sy 1k
CSX sy 0 10p IC=0
ESB so 0 sy 0 1

* (3) relaxation oscillator: comparator output +/-5 V; C on the - input, R_1 = R_2 divider on the + input
BO ox 0 V = 5*tanh(1e6*(V(op) - V(cap)))
ROX ox oy 1k
COX oy 0 10p IC=5
EOB oo 0 oy 0 1
RO oo cap 47k
CO cap 0 10n IC=0
RO1 op 0 10k
RO2 oo op 10k

.control
op
let gdc = v(od) / 1m
let voff = v(oc)
echo "gdc = $&gdc"
echo "voff = $&voff"
ac dec 2000 1e-5 10
let za = vm(oa) / vm(oa)[0]
meas ac f3lossy when za=0.7071067811865476 fall=1
echo "f3lossy = $&f3lossy"
ac dec 2000 0.1 1k
let zd = vm(od) / vm(od)[0]
meas ac f3leak when zd=0.7071067811865476 fall=1
echo "f3leak = $&f3leak"
tran 0.1u 6m 0 0.1u uic
meas tran vb1 find v(ob) at=1m
meas tran vb2 find v(ob) at=2m
let ramp = (vb2 - vb1) / 1m
echo "ramp = $&ramp"
meas tran vup find v(sin) when v(so)=2.5 rise=1
meas tran vlo find v(sin) when v(so)=2.5 fall=1
echo "vup = $&vup"
echo "vlo = $&vlo"
meas tran t1 when v(oo)=0 rise=2
meas tran t2 when v(oo)=0 rise=4
let fosc = 2 / (t2 - t1)
echo "fosc = $&fosc"
meas tran vcpk max v(cap) from=2m to=6m
echo "vcpk = $&vcpk"
.endc
.end
