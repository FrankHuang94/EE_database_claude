* Lab 09-09 -- SPICE level-1 (Shichman-Hodges) NMOS with the chapter's parameters.
* Level 1 is the square law with m = 1: I_Dsat = (KP/2)(W/L)(V_GS - V_TH)^2 with the body effect
* V_TH = VTO + GAMMA (sqrt(PHI + V_SB) - sqrt(PHI)), PHI = 2 phi_B. KP = mu_ns C_ox = 315.108 cm^2/Vs x
* 863.283 nF/cm^2 = 2.72027e-4 A/V^2; GAMMA = 0.47192 V^0.5; PHI = 0.91658 V; LAMBDA = 0 (no CLM).
* M1: V_GS = V_DS = 1.2 V, body at source. M2: same, body at -1 V (V_SB = 1 V).
* The temperature is set to 300 K.
*
* EXPECT id0 key:../../chapters/09-09-long-channel-mosfet.md#Ex_09-09.2c scale=1e-3 rtol=2e-3
* EXPECT idb key:../../chapters/09-09-long-channel-mosfet.md#Ex_09-09.3d scale=1e-3 rtol=2e-3

.options temp=26.85 tnom=26.85 reltol=1e-7
VG  g 0 DC 1.2
VD1 d1 0 DC 1.2
VD2 d2 0 DC 1.2
VB  b 0 DC -1.0
M1  d1 g 0 0 nlong W=10u L=1u
M2  d2 g 0 b nlong W=10u L=1u
.model nlong NMOS(LEVEL=1 VTO=0.4 KP=2.72027e-4 GAMMA=0.47192 PHI=0.91658 LAMBDA=0)

.control
op
let id0 = -i(VD1)
let idb = -i(VD2)
echo "id0 = $&id0"
echo "idb = $&idb"
.endc
.end
